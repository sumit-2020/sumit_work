simulator lang=spectre
parameters VDD = 1.8
//tr is (transition time)/2
parameters tr = 1n
//f is the fall time
//parameters f = 100p
//K is the signal period for programming
parameters K = 5u
//L is the signal period for running
parameters L = 0.5u

vVdd (vdd 0) vsource dc=VDD
vGnd (gnd 0) vsource dc=0

vConfig (config 0) vsource type=pwl wave=\[
+ ( 0*K   ) VDD  ( 1*K-tr) VDD
+ ( 1*K+tr) VDD  ( 2*K-tr) VDD
+ ( 2*K+tr) VDD  ( 3*K-tr) VDD
+ ( 3*K+tr) VDD  ( 4*K-tr) VDD
+ ( 4*K+tr) VDD  ( 5*K-tr) VDD
+ ( 5*K+tr) VDD  ( 6*K-tr) VDD
+ ( 6*K+tr) VDD  ( 7*K-tr) VDD
+ ( 7*K+tr) VDD  ( 8*K-tr) VDD
+ ( 8*K+tr) VDD  ( 9*K-tr) VDD
+ ( 9*K+tr) VDD  (10*K-tr) VDD
+ (10*K+tr) VDD  (11*K-tr) VDD
+ (11*K+tr) VDD  (12*K-tr) VDD
+ (12*K+tr) VDD  (13*K-tr) VDD
+ (13*K+tr) VDD  (14*K-tr) VDD
+ (14*K+tr) VDD  (15*K-tr) VDD
+ (15*K+tr) VDD  (16*K-tr) VDD
+ (16*K+tr) VDD  (17*K-tr) VDD
+ (17*K+tr) VDD  (18*K-tr) VDD
+ (18*K+tr) VDD  (19*K-tr) VDD
+ (19*K+tr) VDD  (20*K-tr) VDD
+ (20*K+tr) VDD  (21*K-tr) VDD
+ (21*K+tr) VDD  (22*K-tr) VDD
+ (22*K+tr) VDD  (23*K-tr) VDD
+ (23*K+tr) VDD  (24*K-tr) VDD
+ (24*K+tr) VDD  (25*K-tr) VDD
+ (25*K+tr) VDD  (26*K-tr) VDD
+ (26*K+tr) VDD  (27*K-tr) VDD
+ (27*K+tr) VDD  (28*K-tr) VDD
+ (28*K+tr) VDD  (29*K-tr) VDD
+ (29*K+tr) VDD  (30*K-tr) VDD
+ (30*K+tr) VDD  (31*K-tr) VDD
+ (31*K+tr) VDD  (32*K-tr) VDD
+ (32*K+tr) VDD  (33*K-tr) VDD
+ (33*K+tr) VDD  (34*K-tr) VDD
+ (34*K+tr) VDD  (35*K-tr) VDD
+ (35*K+tr) VDD  (36*K-tr) VDD
+ (36*K+tr) VDD  (37*K-tr) VDD
+ (37*K+tr) VDD  (38*K-tr) VDD
+ (38*K+tr) VDD  (39*K-tr) VDD
+ (39*K+tr) VDD  (40*K-tr) VDD
+ (40*K+tr) VDD  (41*K-tr) VDD
+ (41*K+tr) VDD  (42*K-tr) VDD
+ (42*K+tr) VDD  (43*K-tr) VDD
+ (43*K+tr) VDD  (44*K-tr) VDD
+ (44*K+tr) VDD  (45*K-tr) VDD
+ (45*K+tr) VDD  (46*K-tr) VDD
+ (46*K+tr) VDD  (47*K-tr) VDD
+ (47*K+tr) VDD  (48*K-tr) VDD
+ (48*K+tr) VDD  (49*K-tr) VDD
+ (49*K+tr) VDD  (50*K-tr) VDD
+ (50*K+tr) VDD  (51*K-tr) VDD
+ (51*K+tr) VDD  (52*K-tr) VDD
+ (52*K+tr) VDD  (53*K-tr) VDD
+ (53*K+tr) VDD  (54*K-tr) VDD
+ (54*K+tr) VDD  (55*K-tr) VDD
+ (55*K+tr) VDD  (56*K-tr) VDD
+ (56*K+tr) VDD  (57*K-tr) VDD
+ (57*K+tr) VDD  (58*K-tr) VDD
+ (58*K+tr) VDD  (59*K-tr) VDD
+ (59*K+tr) VDD  (60*K-tr) VDD
+ (60*K+tr) VDD  (61*K-tr) VDD
+ (61*K+tr) VDD  (62*K-tr) VDD
+ (62*K+tr) VDD  (63*K-tr) VDD
+ (63*K+tr) VDD  (64*K-tr) VDD
+ (64*K+tr) VDD  (65*K-tr) VDD
+ (65*K+tr) VDD  (66*K-tr) VDD
+ (66*K+tr) VDD  (67*K-tr) VDD
+ (67*K+tr) VDD  (68*K-tr) VDD
+ (68*K+tr) VDD  (69*K-tr) VDD
+ (69*K+tr) VDD  (70*K-tr) VDD
+ (70*K+tr) VDD  (71*K-tr) VDD
+ (71*K+tr) VDD  (72*K-tr) VDD
+ (72*K+tr) VDD  (73*K-tr) VDD
+ (73*K+tr) VDD  (74*K-tr) VDD
+ (74*K+tr) VDD  (75*K-tr) VDD
+ (75*K+tr) VDD  (76*K-tr) VDD
+ (76*K+tr) VDD  (77*K-tr) VDD
+ (77*K+tr) VDD  (78*K-tr) VDD
+ (78*K+tr) VDD  (79*K-tr) VDD
+ (79*K+tr) VDD  (80*K-tr) VDD
+ (80*K+tr) VDD  (81*K-tr) VDD
+ (81*K+tr) VDD  (82*K-tr) VDD
+ (82*K+tr) VDD  (83*K-tr) VDD
+ (83*K+tr) VDD  (84*K-tr) VDD
+ (84*K+tr) VDD  (85*K-tr) VDD
+ (85*K+tr) VDD  (86*K-tr) VDD
+ (86*K+tr) VDD  (87*K-tr) VDD
+ (87*K+tr) VDD  (88*K-tr) VDD
+ (88*K+tr) VDD  (89*K-tr) VDD
+ (89*K+tr) VDD  (90*K-tr) VDD
+ (90*K+tr) VDD  (91*K-tr) VDD
+ (91*K+tr) VDD  (92*K-tr) VDD
+ (92*K+tr) VDD  (93*K-tr) VDD
+ (93*K+tr) VDD  (94*K-tr) VDD
+ (94*K+tr) VDD  (95*K-tr) VDD
+ (95*K+tr) VDD  (96*K-tr) VDD
+ (96*K+tr) VDD  (97*K-tr) VDD
+ (97*K+tr) VDD  (98*K-tr) VDD
+ (98*K+tr) VDD  (99*K-tr) VDD
+ (99*K+tr) VDD  (100*K-tr) VDD
+ (100*K+tr) VDD  (101*K-tr) VDD
+ (101*K+tr) VDD  (102*K-tr) VDD
+ (102*K+tr) VDD  (103*K-tr) VDD
+ (103*K+tr) VDD  (104*K-tr) VDD
+ (104*K+tr) VDD  (105*K-tr) VDD
+ (105*K+tr) VDD  (106*K-tr) VDD
+ (106*K+tr) VDD  (107*K-tr) VDD
+ (107*K+tr) VDD  (108*K-tr) VDD
+ (108*K+tr) VDD  (109*K-tr) VDD
+ (109*K+tr) VDD  (110*K-tr) VDD
+ (110*K+tr) VDD  (111*K-tr) VDD
+ (111*K+tr) VDD  (112*K-tr) VDD
+ (112*K+tr) VDD  (113*K-tr) VDD
+ (113*K+tr) VDD  (114*K-tr) VDD
+ (114*K+tr) VDD  (115*K-tr) VDD
+ (115*K+tr) VDD  (116*K-tr) VDD
+ (116*K+tr) VDD  (117*K-tr) VDD
+ (117*K+tr) VDD  (118*K-tr) VDD
+ (118*K+tr) VDD  (119*K-tr) VDD
+ (119*K+tr) VDD  (120*K-tr) VDD
+ (120*K+tr) VDD  (121*K-tr) VDD
+ (121*K+tr) VDD  (122*K-tr) VDD
+ (122*K+tr) VDD  (123*K-tr) VDD
+ (123*K+tr) VDD  (124*K-tr) VDD
+ (124*K+tr) VDD  (125*K-tr) VDD
+ (125*K+tr) VDD  (126*K-tr) VDD
+ (126*K+tr) VDD  (127*K-tr) VDD
+ (127*K+tr) VDD  (128*K-tr) VDD
+ (128*K+tr) VDD  (129*K-tr) VDD
+ (129*K+tr) VDD  (130*K-tr) VDD
+ (130*K+tr) VDD  (131*K-tr) VDD
+ (131*K+tr) VDD  (132*K-tr) VDD
+ (132*K+tr) VDD  (133*K-tr) VDD
+ (133*K+tr) VDD  (134*K-tr) VDD
+ (134*K+tr) VDD  (135*K-tr) VDD
+ (135*K+tr) VDD  (136*K-tr) VDD
+ (136*K+tr) VDD  (137*K-tr) VDD
+ (137*K+tr) VDD  (138*K-tr) VDD
+ (138*K+tr) VDD  (139*K-tr) VDD
+ (139*K+tr) VDD  (140*K-tr) VDD
+ (140*K+tr) VDD  (141*K-tr) VDD
+ (141*K+tr) VDD  (142*K-tr) VDD
+ (142*K+tr) VDD  (143*K-tr) VDD
+ (143*K+tr) VDD  (144*K-tr) VDD
+ (144*K+tr) VDD  (145*K-tr) VDD
+ (145*K+tr) VDD  (146*K-tr) VDD
+ (146*K+tr) VDD  (147*K-tr) VDD
+ (147*K+ 0*L+tr) VDD  (147*K+ 1*L-tr) VDD
+ (147*K+ 1*L+tr) 0    (147*K+ 2*L-tr) 0
+ (147*K+ 2*L+tr) 0    (147*K+ 3*L-tr) 0
+ (147*K+ 3*L+tr) 0    (147*K+ 4*L-tr) 0
+ (147*K+ 4*L+tr) 0    (147*K+ 5*L-tr) 0
+ (147*K+ 5*L+tr) 0    (147*K+ 6*L-tr) 0
+ (147*K+ 6*L+tr) 0    (147*K+ 7*L-tr) 0
+ (147*K+ 7*L+tr) 0    (147*K+ 8*L-tr) 0
+ (147*K+ 8*L+tr) 0    (147*K+ 9*L-tr) 0
+ (147*K+ 9*L+tr) 0    (147*K+10*L-tr) 0
+ (147*K+10*L+tr) 0    (147*K+11*L-tr) 0
+ (147*K+11*L+tr) 0    (147*K+12*L-tr) 0
+ (147*K+12*L+tr) 0    (147*K+13*L-tr) 0
+ (147*K+13*L+tr) 0    (147*K+14*L-tr) 0
+ ]
vIO_LEFT_1 (IO_LEFT_1 0) vsource type=pwl wave=\[
+ ( 0*K   ) 0    ( 1*K-tr) 0
+ ( 1*K+tr) 0    ( 2*K-tr) 0
+ ( 2*K+tr) 0    ( 3*K-tr) 0
+ ( 3*K+tr) 0    ( 4*K-tr) 0
+ ( 4*K+tr) 0    ( 5*K-tr) 0
+ ( 5*K+tr) 0    ( 6*K-tr) 0
+ ( 6*K+tr) 0    ( 7*K-tr) 0
+ ( 7*K+tr) 0    ( 8*K-tr) 0
+ ( 8*K+tr) 0    ( 9*K-tr) 0
+ ( 9*K+tr) 0    (10*K-tr) 0
+ (10*K+tr) 0    (11*K-tr) 0
+ (11*K+tr) 0    (12*K-tr) 0
+ (12*K+tr) 0    (13*K-tr) 0
+ (13*K+tr) 0    (14*K-tr) 0
+ (14*K+tr) 0    (15*K-tr) 0
+ (15*K+tr) 0    (16*K-tr) 0
+ (16*K+tr) 0    (17*K-tr) 0
+ (17*K+tr) 0    (18*K-tr) 0
+ (18*K+tr) 0    (19*K-tr) 0
+ (19*K+tr) 0    (20*K-tr) 0
+ (20*K+tr) 0    (21*K-tr) 0
+ (21*K+tr) 0    (22*K-tr) 0
+ (22*K+tr) 0    (23*K-tr) 0
+ (23*K+tr) 0    (24*K-tr) 0
+ (24*K+tr) 0    (25*K-tr) 0
+ (25*K+tr) 0    (26*K-tr) 0
+ (26*K+tr) 0    (27*K-tr) 0
+ (27*K+tr) 0    (28*K-tr) 0
+ (28*K+tr) 0    (29*K-tr) 0
+ (29*K+tr) 0    (30*K-tr) 0
+ (30*K+tr) 0    (31*K-tr) 0
+ (31*K+tr) 0    (32*K-tr) 0
+ (32*K+tr) 0    (33*K-tr) 0
+ (33*K+tr) 0    (34*K-tr) 0
+ (34*K+tr) 0    (35*K-tr) 0
+ (35*K+tr) 0    (36*K-tr) 0
+ (36*K+tr) 0    (37*K-tr) 0
+ (37*K+tr) 0    (38*K-tr) 0
+ (38*K+tr) 0    (39*K-tr) 0
+ (39*K+tr) 0    (40*K-tr) 0
+ (40*K+tr) 0    (41*K-tr) 0
+ (41*K+tr) 0    (42*K-tr) 0
+ (42*K+tr) 0    (43*K-tr) 0
+ (43*K+tr) 0    (44*K-tr) 0
+ (44*K+tr) 0    (45*K-tr) 0
+ (45*K+tr) 0    (46*K-tr) 0
+ (46*K+tr) 0    (47*K-tr) 0
+ (47*K+tr) 0    (48*K-tr) 0
+ (48*K+tr) 0    (49*K-tr) 0
+ (49*K+tr) 0    (50*K-tr) 0
+ (50*K+tr) 0    (51*K-tr) 0
+ (51*K+tr) 0    (52*K-tr) 0
+ (52*K+tr) 0    (53*K-tr) 0
+ (53*K+tr) 0    (54*K-tr) 0
+ (54*K+tr) 0    (55*K-tr) 0
+ (55*K+tr) 0    (56*K-tr) 0
+ (56*K+tr) 0    (57*K-tr) 0
+ (57*K+tr) 0    (58*K-tr) 0
+ (58*K+tr) 0    (59*K-tr) 0
+ (59*K+tr) 0    (60*K-tr) 0
+ (60*K+tr) VDD  (61*K-tr) VDD
+ (61*K+tr) 0    (62*K-tr) 0
+ (62*K+tr) VDD  (63*K-tr) VDD
+ (63*K+tr) VDD  (64*K-tr) VDD
+ (64*K+tr) 0    (65*K-tr) 0
+ (65*K+tr) VDD  (66*K-tr) VDD
+ (66*K+tr) 0    (67*K-tr) 0
+ (67*K+tr) 0    (68*K-tr) 0
+ (68*K+tr) 0    (69*K-tr) 0
+ (69*K+tr) VDD  (70*K-tr) VDD
+ (70*K+tr) 0    (71*K-tr) 0
+ (71*K+tr) VDD  (72*K-tr) VDD
+ (72*K+tr) VDD  (73*K-tr) VDD
+ (73*K+tr) VDD  (74*K-tr) VDD
+ (74*K+tr) 0    (75*K-tr) 0
+ (75*K+tr) VDD  (76*K-tr) VDD
+ (76*K+tr) VDD  (77*K-tr) VDD
+ (77*K+tr) 0    (78*K-tr) 0
+ (78*K+tr) VDD  (79*K-tr) VDD
+ (79*K+tr) 0    (80*K-tr) 0
+ (80*K+tr) 0    (81*K-tr) 0
+ (81*K+tr) 0    (82*K-tr) 0
+ (82*K+tr) VDD  (83*K-tr) VDD
+ (83*K+tr) 0    (84*K-tr) 0
+ (84*K+tr) VDD  (85*K-tr) VDD
+ (85*K+tr) VDD  (86*K-tr) VDD
+ (86*K+tr) VDD  (87*K-tr) VDD
+ (87*K+tr) 0    (88*K-tr) 0
+ (88*K+tr) VDD  (89*K-tr) VDD
+ (89*K+tr) VDD  (90*K-tr) VDD
+ (90*K+tr) 0    (91*K-tr) 0
+ (91*K+tr) VDD  (92*K-tr) VDD
+ (92*K+tr) 0    (93*K-tr) 0
+ (93*K+tr) 0    (94*K-tr) 0
+ (94*K+tr) 0    (95*K-tr) 0
+ (95*K+tr) VDD  (96*K-tr) VDD
+ (96*K+tr) 0    (97*K-tr) 0
+ (97*K+tr) VDD  (98*K-tr) VDD
+ (98*K+tr) VDD  (99*K-tr) VDD
+ (99*K+tr) VDD  (100*K-tr) VDD
+ (100*K+tr) 0    (101*K-tr) 0
+ (101*K+tr) VDD  (102*K-tr) VDD
+ (102*K+tr) VDD  (103*K-tr) VDD
+ (103*K+tr) 0    (104*K-tr) 0
+ (104*K+tr) VDD  (105*K-tr) VDD
+ (105*K+tr) 0    (106*K-tr) 0
+ (106*K+tr) 0    (107*K-tr) 0
+ (107*K+tr) 0    (108*K-tr) 0
+ (108*K+tr) VDD  (109*K-tr) VDD
+ (109*K+tr) 0    (110*K-tr) 0
+ (110*K+tr) VDD  (111*K-tr) VDD
+ (111*K+tr) VDD  (112*K-tr) VDD
+ (112*K+tr) VDD  (113*K-tr) VDD
+ (113*K+tr) 0    (114*K-tr) 0
+ (114*K+tr) VDD  (115*K-tr) VDD
+ (115*K+tr) VDD  (116*K-tr) VDD
+ (116*K+tr) 0    (117*K-tr) 0
+ (117*K+tr) VDD  (118*K-tr) VDD
+ (118*K+tr) 0    (119*K-tr) 0
+ (119*K+tr) 0    (120*K-tr) 0
+ (120*K+tr) 0    (121*K-tr) 0
+ (121*K+tr) VDD  (122*K-tr) VDD
+ (122*K+tr) 0    (123*K-tr) 0
+ (123*K+tr) VDD  (124*K-tr) VDD
+ (124*K+tr) VDD  (125*K-tr) VDD
+ (125*K+tr) VDD  (126*K-tr) VDD
+ (126*K+tr) 0    (127*K-tr) 0
+ (127*K+tr) VDD  (128*K-tr) VDD
+ (128*K+tr) VDD  (129*K-tr) VDD
+ (129*K+tr) 0    (130*K-tr) 0
+ (130*K+tr) VDD  (131*K-tr) VDD
+ (131*K+tr) 0    (132*K-tr) 0
+ (132*K+tr) 0    (133*K-tr) 0
+ (133*K+tr) 0    (134*K-tr) 0
+ (134*K+tr) VDD  (135*K-tr) VDD
+ (135*K+tr) 0    (136*K-tr) 0
+ (136*K+tr) VDD  (137*K-tr) VDD
+ (137*K+tr) VDD  (138*K-tr) VDD
+ (138*K+tr) VDD  (139*K-tr) VDD
+ (139*K+tr) 0    (140*K-tr) 0
+ (140*K+tr) VDD  (141*K-tr) VDD
+ (141*K+tr) VDD  (142*K-tr) VDD
+ (142*K+tr) 0    (143*K-tr) 0
+ (143*K+tr) 0    (144*K-tr) 0
+ (144*K+tr) 0    (145*K-tr) 0
+ (145*K+tr) 0    (146*K-tr) 0
+ (146*K+tr) 0    (147*K-tr) 0
+ (147*K+ 0*L+tr) VDD  (147*K+ 1*L-tr) VDD
+ (147*K+ 1*L+tr) 0    (147*K+ 2*L-tr) 0
+ (147*K+ 2*L+tr) VDD  (147*K+ 3*L-tr) VDD
+ (147*K+ 3*L+tr) VDD  (147*K+ 4*L-tr) VDD
+ (147*K+ 4*L+tr) 0    (147*K+ 5*L-tr) 0
+ (147*K+ 5*L+tr) VDD  (147*K+ 6*L-tr) VDD
+ (147*K+ 6*L+tr) 0    (147*K+ 7*L-tr) 0
+ (147*K+ 7*L+tr) 0    (147*K+ 8*L-tr) 0
+ (147*K+ 8*L+tr) 0    (147*K+ 9*L-tr) 0
+ (147*K+ 9*L+tr) VDD  (147*K+10*L-tr) VDD
+ (147*K+10*L+tr) 0    (147*K+11*L-tr) 0
+ (147*K+11*L+tr) VDD  (147*K+12*L-tr) VDD
+ (147*K+12*L+tr) VDD  (147*K+13*L-tr) VDD
+ (147*K+13*L+tr) VDD  (147*K+14*L-tr) VDD
+ ]
vIO_TOP_1 (IO_TOP_1 0) vsource type=pwl wave=\[
+ ( 0*K   ) 0    ( 1*K-tr) 0
+ ( 1*K+tr) 0    ( 2*K-tr) 0
+ ( 2*K+tr) 0    ( 3*K-tr) 0
+ ( 3*K+tr) 0    ( 4*K-tr) 0
+ ( 4*K+tr) 0    ( 5*K-tr) 0
+ ( 5*K+tr) 0    ( 6*K-tr) 0
+ ( 6*K+tr) 0    ( 7*K-tr) 0
+ ( 7*K+tr) 0    ( 8*K-tr) 0
+ ( 8*K+tr) 0    ( 9*K-tr) 0
+ ( 9*K+tr) 0    (10*K-tr) 0
+ (10*K+tr) 0    (11*K-tr) 0
+ (11*K+tr) 0    (12*K-tr) 0
+ (12*K+tr) 0    (13*K-tr) 0
+ (13*K+tr) 0    (14*K-tr) 0
+ (14*K+tr) 0    (15*K-tr) 0
+ (15*K+tr) 0    (16*K-tr) 0
+ (16*K+tr) 0    (17*K-tr) 0
+ (17*K+tr) 0    (18*K-tr) 0
+ (18*K+tr) 0    (19*K-tr) 0
+ (19*K+tr) 0    (20*K-tr) 0
+ (20*K+tr) 0    (21*K-tr) 0
+ (21*K+tr) 0    (22*K-tr) 0
+ (22*K+tr) 0    (23*K-tr) 0
+ (23*K+tr) 0    (24*K-tr) 0
+ (24*K+tr) 0    (25*K-tr) 0
+ (25*K+tr) 0    (26*K-tr) 0
+ (26*K+tr) 0    (27*K-tr) 0
+ (27*K+tr) 0    (28*K-tr) 0
+ (28*K+tr) 0    (29*K-tr) 0
+ (29*K+tr) 0    (30*K-tr) 0
+ (30*K+tr) 0    (31*K-tr) 0
+ (31*K+tr) 0    (32*K-tr) 0
+ (32*K+tr) 0    (33*K-tr) 0
+ (33*K+tr) 0    (34*K-tr) 0
+ (34*K+tr) 0    (35*K-tr) 0
+ (35*K+tr) 0    (36*K-tr) 0
+ (36*K+tr) 0    (37*K-tr) 0
+ (37*K+tr) 0    (38*K-tr) 0
+ (38*K+tr) 0    (39*K-tr) 0
+ (39*K+tr) 0    (40*K-tr) 0
+ (40*K+tr) 0    (41*K-tr) 0
+ (41*K+tr) 0    (42*K-tr) 0
+ (42*K+tr) 0    (43*K-tr) 0
+ (43*K+tr) 0    (44*K-tr) 0
+ (44*K+tr) 0    (45*K-tr) 0
+ (45*K+tr) 0    (46*K-tr) 0
+ (46*K+tr) 0    (47*K-tr) 0
+ (47*K+tr) 0    (48*K-tr) 0
+ (48*K+tr) 0    (49*K-tr) 0
+ (49*K+tr) 0    (50*K-tr) 0
+ (50*K+tr) 0    (51*K-tr) 0
+ (51*K+tr) 0    (52*K-tr) 0
+ (52*K+tr) 0    (53*K-tr) 0
+ (53*K+tr) 0    (54*K-tr) 0
+ (54*K+tr) 0    (55*K-tr) 0
+ (55*K+tr) 0    (56*K-tr) 0
+ (56*K+tr) 0    (57*K-tr) 0
+ (57*K+tr) 0    (58*K-tr) 0
+ (58*K+tr) 0    (59*K-tr) 0
+ (59*K+tr) 0    (60*K-tr) 0
+ (60*K+tr) 0    (61*K-tr) 0
+ (61*K+tr) 0    (62*K-tr) 0
+ (62*K+tr) VDD  (63*K-tr) VDD
+ (63*K+tr) VDD  (64*K-tr) VDD
+ (64*K+tr) 0    (65*K-tr) 0
+ (65*K+tr) VDD  (66*K-tr) VDD
+ (66*K+tr) 0    (67*K-tr) 0
+ (67*K+tr) VDD  (68*K-tr) VDD
+ (68*K+tr) 0    (69*K-tr) 0
+ (69*K+tr) 0    (70*K-tr) 0
+ (70*K+tr) 0    (71*K-tr) 0
+ (71*K+tr) VDD  (72*K-tr) VDD
+ (72*K+tr) 0    (73*K-tr) 0
+ (73*K+tr) VDD  (74*K-tr) VDD
+ (74*K+tr) 0    (75*K-tr) 0
+ (75*K+tr) 0    (76*K-tr) 0
+ (76*K+tr) VDD  (77*K-tr) VDD
+ (77*K+tr) VDD  (78*K-tr) VDD
+ (78*K+tr) 0    (79*K-tr) 0
+ (79*K+tr) VDD  (80*K-tr) VDD
+ (80*K+tr) 0    (81*K-tr) 0
+ (81*K+tr) VDD  (82*K-tr) VDD
+ (82*K+tr) 0    (83*K-tr) 0
+ (83*K+tr) 0    (84*K-tr) 0
+ (84*K+tr) 0    (85*K-tr) 0
+ (85*K+tr) VDD  (86*K-tr) VDD
+ (86*K+tr) 0    (87*K-tr) 0
+ (87*K+tr) VDD  (88*K-tr) VDD
+ (88*K+tr) 0    (89*K-tr) 0
+ (89*K+tr) 0    (90*K-tr) 0
+ (90*K+tr) VDD  (91*K-tr) VDD
+ (91*K+tr) VDD  (92*K-tr) VDD
+ (92*K+tr) 0    (93*K-tr) 0
+ (93*K+tr) VDD  (94*K-tr) VDD
+ (94*K+tr) 0    (95*K-tr) 0
+ (95*K+tr) VDD  (96*K-tr) VDD
+ (96*K+tr) 0    (97*K-tr) 0
+ (97*K+tr) 0    (98*K-tr) 0
+ (98*K+tr) 0    (99*K-tr) 0
+ (99*K+tr) VDD  (100*K-tr) VDD
+ (100*K+tr) 0    (101*K-tr) 0
+ (101*K+tr) VDD  (102*K-tr) VDD
+ (102*K+tr) 0    (103*K-tr) 0
+ (103*K+tr) 0    (104*K-tr) 0
+ (104*K+tr) VDD  (105*K-tr) VDD
+ (105*K+tr) VDD  (106*K-tr) VDD
+ (106*K+tr) 0    (107*K-tr) 0
+ (107*K+tr) VDD  (108*K-tr) VDD
+ (108*K+tr) 0    (109*K-tr) 0
+ (109*K+tr) VDD  (110*K-tr) VDD
+ (110*K+tr) 0    (111*K-tr) 0
+ (111*K+tr) 0    (112*K-tr) 0
+ (112*K+tr) 0    (113*K-tr) 0
+ (113*K+tr) VDD  (114*K-tr) VDD
+ (114*K+tr) 0    (115*K-tr) 0
+ (115*K+tr) VDD  (116*K-tr) VDD
+ (116*K+tr) 0    (117*K-tr) 0
+ (117*K+tr) 0    (118*K-tr) 0
+ (118*K+tr) VDD  (119*K-tr) VDD
+ (119*K+tr) VDD  (120*K-tr) VDD
+ (120*K+tr) 0    (121*K-tr) 0
+ (121*K+tr) VDD  (122*K-tr) VDD
+ (122*K+tr) 0    (123*K-tr) 0
+ (123*K+tr) VDD  (124*K-tr) VDD
+ (124*K+tr) 0    (125*K-tr) 0
+ (125*K+tr) 0    (126*K-tr) 0
+ (126*K+tr) 0    (127*K-tr) 0
+ (127*K+tr) VDD  (128*K-tr) VDD
+ (128*K+tr) 0    (129*K-tr) 0
+ (129*K+tr) VDD  (130*K-tr) VDD
+ (130*K+tr) 0    (131*K-tr) 0
+ (131*K+tr) 0    (132*K-tr) 0
+ (132*K+tr) VDD  (133*K-tr) VDD
+ (133*K+tr) VDD  (134*K-tr) VDD
+ (134*K+tr) 0    (135*K-tr) 0
+ (135*K+tr) VDD  (136*K-tr) VDD
+ (136*K+tr) 0    (137*K-tr) 0
+ (137*K+tr) VDD  (138*K-tr) VDD
+ (138*K+tr) 0    (139*K-tr) 0
+ (139*K+tr) 0    (140*K-tr) 0
+ (140*K+tr) 0    (141*K-tr) 0
+ (141*K+tr) VDD  (142*K-tr) VDD
+ (142*K+tr) 0    (143*K-tr) 0
+ (143*K+tr) VDD  (144*K-tr) VDD
+ (144*K+tr) 0    (145*K-tr) 0
+ (145*K+tr) 0    (146*K-tr) 0
+ (146*K+tr) 0    (147*K-tr) 0
+ (147*K+ 0*L+tr) 0    (147*K+ 1*L-tr) 0
+ (147*K+ 1*L+tr) VDD  (147*K+ 2*L-tr) VDD
+ (147*K+ 2*L+tr) VDD  (147*K+ 3*L-tr) VDD
+ (147*K+ 3*L+tr) 0    (147*K+ 4*L-tr) 0
+ (147*K+ 4*L+tr) VDD  (147*K+ 5*L-tr) VDD
+ (147*K+ 5*L+tr) 0    (147*K+ 6*L-tr) 0
+ (147*K+ 6*L+tr) VDD  (147*K+ 7*L-tr) VDD
+ (147*K+ 7*L+tr) 0    (147*K+ 8*L-tr) 0
+ (147*K+ 8*L+tr) 0    (147*K+ 9*L-tr) 0
+ (147*K+ 9*L+tr) 0    (147*K+10*L-tr) 0
+ (147*K+10*L+tr) VDD  (147*K+11*L-tr) VDD
+ (147*K+11*L+tr) 0    (147*K+12*L-tr) 0
+ (147*K+12*L+tr) VDD  (147*K+13*L-tr) VDD
+ (147*K+13*L+tr) 0    (147*K+14*L-tr) 0
+ ]
vCLK (CLK 0) vsource type=pwl wave=\[
+ ( 0*K   ) 0    ( 1*K-tr) 0
+ ( 1*K+tr) 0    ( 2*K-tr) 0
+ ( 2*K+tr) 0    ( 3*K-tr) 0
+ ( 3*K+tr) VDD  ( 4*K-tr) VDD
+ ( 4*K+tr) VDD  ( 5*K-tr) VDD
+ ( 5*K+tr) VDD  ( 6*K-tr) VDD
+ ( 6*K+tr) 0    ( 7*K-tr) 0
+ ( 7*K+tr) 0    ( 8*K-tr) 0
+ ( 8*K+tr) 0    ( 9*K-tr) 0
+ ( 9*K+tr) VDD  (10*K-tr) VDD
+ (10*K+tr) VDD  (11*K-tr) VDD
+ (11*K+tr) VDD  (12*K-tr) VDD
+ (12*K+tr) 0    (13*K-tr) 0
+ (13*K+tr) 0    (14*K-tr) 0
+ (14*K+tr) 0    (15*K-tr) 0
+ (15*K+tr) VDD  (16*K-tr) VDD
+ (16*K+tr) VDD  (17*K-tr) VDD
+ (17*K+tr) VDD  (18*K-tr) VDD
+ (18*K+tr) 0    (19*K-tr) 0
+ (19*K+tr) 0    (20*K-tr) 0
+ (20*K+tr) 0    (21*K-tr) 0
+ (21*K+tr) VDD  (22*K-tr) VDD
+ (22*K+tr) VDD  (23*K-tr) VDD
+ (23*K+tr) VDD  (24*K-tr) VDD
+ (24*K+tr) 0    (25*K-tr) 0
+ (25*K+tr) 0    (26*K-tr) 0
+ (26*K+tr) 0    (27*K-tr) 0
+ (27*K+tr) VDD  (28*K-tr) VDD
+ (28*K+tr) VDD  (29*K-tr) VDD
+ (29*K+tr) VDD  (30*K-tr) VDD
+ (30*K+tr) 0    (31*K-tr) 0
+ (31*K+tr) 0    (32*K-tr) 0
+ (32*K+tr) 0    (33*K-tr) 0
+ (33*K+tr) VDD  (34*K-tr) VDD
+ (34*K+tr) VDD  (35*K-tr) VDD
+ (35*K+tr) VDD  (36*K-tr) VDD
+ (36*K+tr) 0    (37*K-tr) 0
+ (37*K+tr) 0    (38*K-tr) 0
+ (38*K+tr) 0    (39*K-tr) 0
+ (39*K+tr) VDD  (40*K-tr) VDD
+ (40*K+tr) VDD  (41*K-tr) VDD
+ (41*K+tr) VDD  (42*K-tr) VDD
+ (42*K+tr) 0    (43*K-tr) 0
+ (43*K+tr) 0    (44*K-tr) 0
+ (44*K+tr) 0    (45*K-tr) 0
+ (45*K+tr) VDD  (46*K-tr) VDD
+ (46*K+tr) VDD  (47*K-tr) VDD
+ (47*K+tr) VDD  (48*K-tr) VDD
+ (48*K+tr) 0    (49*K-tr) 0
+ (49*K+tr) 0    (50*K-tr) 0
+ (50*K+tr) 0    (51*K-tr) 0
+ (51*K+tr) VDD  (52*K-tr) VDD
+ (52*K+tr) VDD  (53*K-tr) VDD
+ (53*K+tr) VDD  (54*K-tr) VDD
+ (54*K+tr) 0    (55*K-tr) 0
+ (55*K+tr) 0    (56*K-tr) 0
+ (56*K+tr) 0    (57*K-tr) 0
+ (57*K+tr) VDD  (58*K-tr) VDD
+ (58*K+tr) VDD  (59*K-tr) VDD
+ (59*K+tr) VDD  (60*K-tr) VDD
+ (60*K+tr) 0    (61*K-tr) 0
+ (61*K+tr) 0    (62*K-tr) 0
+ (62*K+tr) 0    (63*K-tr) 0
+ (63*K+tr) VDD  (64*K-tr) VDD
+ (64*K+tr) VDD  (65*K-tr) VDD
+ (65*K+tr) VDD  (66*K-tr) VDD
+ (66*K+tr) 0    (67*K-tr) 0
+ (67*K+tr) 0    (68*K-tr) 0
+ (68*K+tr) 0    (69*K-tr) 0
+ (69*K+tr) VDD  (70*K-tr) VDD
+ (70*K+tr) VDD  (71*K-tr) VDD
+ (71*K+tr) VDD  (72*K-tr) VDD
+ (72*K+tr) 0    (73*K-tr) 0
+ (73*K+tr) 0    (74*K-tr) 0
+ (74*K+tr) 0    (75*K-tr) 0
+ (75*K+tr) VDD  (76*K-tr) VDD
+ (76*K+tr) VDD  (77*K-tr) VDD
+ (77*K+tr) VDD  (78*K-tr) VDD
+ (78*K+tr) 0    (79*K-tr) 0
+ (79*K+tr) 0    (80*K-tr) 0
+ (80*K+tr) 0    (81*K-tr) 0
+ (81*K+tr) VDD  (82*K-tr) VDD
+ (82*K+tr) VDD  (83*K-tr) VDD
+ (83*K+tr) VDD  (84*K-tr) VDD
+ (84*K+tr) 0    (85*K-tr) 0
+ (85*K+tr) 0    (86*K-tr) 0
+ (86*K+tr) 0    (87*K-tr) 0
+ (87*K+tr) VDD  (88*K-tr) VDD
+ (88*K+tr) VDD  (89*K-tr) VDD
+ (89*K+tr) VDD  (90*K-tr) VDD
+ (90*K+tr) 0    (91*K-tr) 0
+ (91*K+tr) 0    (92*K-tr) 0
+ (92*K+tr) 0    (93*K-tr) 0
+ (93*K+tr) VDD  (94*K-tr) VDD
+ (94*K+tr) VDD  (95*K-tr) VDD
+ (95*K+tr) VDD  (96*K-tr) VDD
+ (96*K+tr) 0    (97*K-tr) 0
+ (97*K+tr) 0    (98*K-tr) 0
+ (98*K+tr) 0    (99*K-tr) 0
+ (99*K+tr) VDD  (100*K-tr) VDD
+ (100*K+tr) VDD  (101*K-tr) VDD
+ (101*K+tr) VDD  (102*K-tr) VDD
+ (102*K+tr) 0    (103*K-tr) 0
+ (103*K+tr) 0    (104*K-tr) 0
+ (104*K+tr) 0    (105*K-tr) 0
+ (105*K+tr) VDD  (106*K-tr) VDD
+ (106*K+tr) VDD  (107*K-tr) VDD
+ (107*K+tr) VDD  (108*K-tr) VDD
+ (108*K+tr) 0    (109*K-tr) 0
+ (109*K+tr) 0    (110*K-tr) 0
+ (110*K+tr) 0    (111*K-tr) 0
+ (111*K+tr) VDD  (112*K-tr) VDD
+ (112*K+tr) VDD  (113*K-tr) VDD
+ (113*K+tr) VDD  (114*K-tr) VDD
+ (114*K+tr) 0    (115*K-tr) 0
+ (115*K+tr) 0    (116*K-tr) 0
+ (116*K+tr) 0    (117*K-tr) 0
+ (117*K+tr) VDD  (118*K-tr) VDD
+ (118*K+tr) VDD  (119*K-tr) VDD
+ (119*K+tr) VDD  (120*K-tr) VDD
+ (120*K+tr) 0    (121*K-tr) 0
+ (121*K+tr) 0    (122*K-tr) 0
+ (122*K+tr) 0    (123*K-tr) 0
+ (123*K+tr) VDD  (124*K-tr) VDD
+ (124*K+tr) VDD  (125*K-tr) VDD
+ (125*K+tr) VDD  (126*K-tr) VDD
+ (126*K+tr) 0    (127*K-tr) 0
+ (127*K+tr) 0    (128*K-tr) 0
+ (128*K+tr) 0    (129*K-tr) 0
+ (129*K+tr) VDD  (130*K-tr) VDD
+ (130*K+tr) VDD  (131*K-tr) VDD
+ (131*K+tr) VDD  (132*K-tr) VDD
+ (132*K+tr) 0    (133*K-tr) 0
+ (133*K+tr) 0    (134*K-tr) 0
+ (134*K+tr) 0    (135*K-tr) 0
+ (135*K+tr) VDD  (136*K-tr) VDD
+ (136*K+tr) VDD  (137*K-tr) VDD
+ (137*K+tr) VDD  (138*K-tr) VDD
+ (138*K+tr) 0    (139*K-tr) 0
+ (139*K+tr) 0    (140*K-tr) 0
+ (140*K+tr) 0    (141*K-tr) 0
+ (141*K+tr) VDD  (142*K-tr) VDD
+ (142*K+tr) VDD  (143*K-tr) VDD
+ (143*K+tr) VDD  (144*K-tr) VDD
+ (144*K+tr) 0    (145*K-tr) 0
+ (145*K+tr) 0    (146*K-tr) 0
+ (146*K+tr) 0    (147*K-tr) 0
+ (147*K+ 0*L+tr) VDD  (147*K+ 1*L-tr) VDD
+ (147*K+ 1*L+tr) VDD  (147*K+ 2*L-tr) VDD
+ (147*K+ 2*L+tr) VDD  (147*K+ 3*L-tr) VDD
+ (147*K+ 3*L+tr) 0    (147*K+ 4*L-tr) 0
+ (147*K+ 4*L+tr) 0    (147*K+ 5*L-tr) 0
+ (147*K+ 5*L+tr) 0    (147*K+ 6*L-tr) 0
+ (147*K+ 6*L+tr) VDD  (147*K+ 7*L-tr) VDD
+ (147*K+ 7*L+tr) VDD  (147*K+ 8*L-tr) VDD
+ (147*K+ 8*L+tr) VDD  (147*K+ 9*L-tr) VDD
+ (147*K+ 9*L+tr) 0    (147*K+10*L-tr) 0
+ (147*K+10*L+tr) 0    (147*K+11*L-tr) 0
+ (147*K+11*L+tr) 0    (147*K+12*L-tr) 0
+ (147*K+12*L+tr) VDD  (147*K+13*L-tr) VDD
+ (147*K+13*L+tr) VDD  (147*K+14*L-tr) VDD
+ ]
vA0 (A0 0) vsource type=pwl wave=\[
+ ( 0*K   ) 0    ( 1*K-tr) 0
+ ( 1*K+tr) 0    ( 2*K-tr) 0
+ ( 2*K+tr) 0    ( 3*K-tr) 0
+ ( 3*K+tr) 0    ( 4*K-tr) 0
+ ( 4*K+tr) VDD  ( 5*K-tr) VDD
+ ( 5*K+tr) 0    ( 6*K-tr) 0
+ ( 6*K+tr) VDD  ( 7*K-tr) VDD
+ ( 7*K+tr) 0    ( 8*K-tr) 0
+ ( 8*K+tr) VDD  ( 9*K-tr) VDD
+ ( 9*K+tr) 0    (10*K-tr) 0
+ (10*K+tr) VDD  (11*K-tr) VDD
+ (11*K+tr) 0    (12*K-tr) 0
+ (12*K+tr) 0    (13*K-tr) 0
+ (13*K+tr) VDD  (14*K-tr) VDD
+ (14*K+tr) 0    (15*K-tr) 0
+ (15*K+tr) VDD  (16*K-tr) VDD
+ (16*K+tr) 0    (17*K-tr) 0
+ (17*K+tr) VDD  (18*K-tr) VDD
+ (18*K+tr) 0    (19*K-tr) 0
+ (19*K+tr) VDD  (20*K-tr) VDD
+ (20*K+tr) 0    (21*K-tr) 0
+ (21*K+tr) 0    (22*K-tr) 0
+ (22*K+tr) VDD  (23*K-tr) VDD
+ (23*K+tr) 0    (24*K-tr) 0
+ (24*K+tr) VDD  (25*K-tr) VDD
+ (25*K+tr) 0    (26*K-tr) 0
+ (26*K+tr) VDD  (27*K-tr) VDD
+ (27*K+tr) 0    (28*K-tr) 0
+ (28*K+tr) VDD  (29*K-tr) VDD
+ (29*K+tr) 0    (30*K-tr) 0
+ (30*K+tr) 0    (31*K-tr) 0
+ (31*K+tr) VDD  (32*K-tr) VDD
+ (32*K+tr) 0    (33*K-tr) 0
+ (33*K+tr) VDD  (34*K-tr) VDD
+ (34*K+tr) 0    (35*K-tr) 0
+ (35*K+tr) VDD  (36*K-tr) VDD
+ (36*K+tr) 0    (37*K-tr) 0
+ (37*K+tr) VDD  (38*K-tr) VDD
+ (38*K+tr) 0    (39*K-tr) 0
+ (39*K+tr) 0    (40*K-tr) 0
+ (40*K+tr) VDD  (41*K-tr) VDD
+ (41*K+tr) 0    (42*K-tr) 0
+ (42*K+tr) VDD  (43*K-tr) VDD
+ (43*K+tr) 0    (44*K-tr) 0
+ (44*K+tr) VDD  (45*K-tr) VDD
+ (45*K+tr) 0    (46*K-tr) 0
+ (46*K+tr) VDD  (47*K-tr) VDD
+ (47*K+tr) 0    (48*K-tr) 0
+ (48*K+tr) 0    (49*K-tr) 0
+ (49*K+tr) VDD  (50*K-tr) VDD
+ (50*K+tr) 0    (51*K-tr) 0
+ (51*K+tr) VDD  (52*K-tr) VDD
+ (52*K+tr) 0    (53*K-tr) 0
+ (53*K+tr) VDD  (54*K-tr) VDD
+ (54*K+tr) 0    (55*K-tr) 0
+ (55*K+tr) VDD  (56*K-tr) VDD
+ (56*K+tr) 0    (57*K-tr) 0
+ (57*K+tr) 0    (58*K-tr) 0
+ (58*K+tr) VDD  (59*K-tr) VDD
+ (59*K+tr) 0    (60*K-tr) 0
+ (60*K+tr) VDD  (61*K-tr) VDD
+ (61*K+tr) 0    (62*K-tr) 0
+ (62*K+tr) VDD  (63*K-tr) VDD
+ (63*K+tr) 0    (64*K-tr) 0
+ (64*K+tr) VDD  (65*K-tr) VDD
+ (65*K+tr) 0    (66*K-tr) 0
+ (66*K+tr) 0    (67*K-tr) 0
+ (67*K+tr) VDD  (68*K-tr) VDD
+ (68*K+tr) 0    (69*K-tr) 0
+ (69*K+tr) VDD  (70*K-tr) VDD
+ (70*K+tr) 0    (71*K-tr) 0
+ (71*K+tr) VDD  (72*K-tr) VDD
+ (72*K+tr) 0    (73*K-tr) 0
+ (73*K+tr) VDD  (74*K-tr) VDD
+ (74*K+tr) 0    (75*K-tr) 0
+ (75*K+tr) 0    (76*K-tr) 0
+ (76*K+tr) VDD  (77*K-tr) VDD
+ (77*K+tr) 0    (78*K-tr) 0
+ (78*K+tr) VDD  (79*K-tr) VDD
+ (79*K+tr) 0    (80*K-tr) 0
+ (80*K+tr) VDD  (81*K-tr) VDD
+ (81*K+tr) 0    (82*K-tr) 0
+ (82*K+tr) VDD  (83*K-tr) VDD
+ (83*K+tr) 0    (84*K-tr) 0
+ (84*K+tr) 0    (85*K-tr) 0
+ (85*K+tr) VDD  (86*K-tr) VDD
+ (86*K+tr) 0    (87*K-tr) 0
+ (87*K+tr) VDD  (88*K-tr) VDD
+ (88*K+tr) 0    (89*K-tr) 0
+ (89*K+tr) VDD  (90*K-tr) VDD
+ (90*K+tr) 0    (91*K-tr) 0
+ (91*K+tr) VDD  (92*K-tr) VDD
+ (92*K+tr) 0    (93*K-tr) 0
+ (93*K+tr) 0    (94*K-tr) 0
+ (94*K+tr) VDD  (95*K-tr) VDD
+ (95*K+tr) 0    (96*K-tr) 0
+ (96*K+tr) VDD  (97*K-tr) VDD
+ (97*K+tr) 0    (98*K-tr) 0
+ (98*K+tr) VDD  (99*K-tr) VDD
+ (99*K+tr) 0    (100*K-tr) 0
+ (100*K+tr) VDD  (101*K-tr) VDD
+ (101*K+tr) 0    (102*K-tr) 0
+ (102*K+tr) 0    (103*K-tr) 0
+ (103*K+tr) VDD  (104*K-tr) VDD
+ (104*K+tr) 0    (105*K-tr) 0
+ (105*K+tr) VDD  (106*K-tr) VDD
+ (106*K+tr) 0    (107*K-tr) 0
+ (107*K+tr) VDD  (108*K-tr) VDD
+ (108*K+tr) 0    (109*K-tr) 0
+ (109*K+tr) VDD  (110*K-tr) VDD
+ (110*K+tr) 0    (111*K-tr) 0
+ (111*K+tr) 0    (112*K-tr) 0
+ (112*K+tr) VDD  (113*K-tr) VDD
+ (113*K+tr) 0    (114*K-tr) 0
+ (114*K+tr) VDD  (115*K-tr) VDD
+ (115*K+tr) 0    (116*K-tr) 0
+ (116*K+tr) VDD  (117*K-tr) VDD
+ (117*K+tr) 0    (118*K-tr) 0
+ (118*K+tr) VDD  (119*K-tr) VDD
+ (119*K+tr) 0    (120*K-tr) 0
+ (120*K+tr) 0    (121*K-tr) 0
+ (121*K+tr) VDD  (122*K-tr) VDD
+ (122*K+tr) 0    (123*K-tr) 0
+ (123*K+tr) VDD  (124*K-tr) VDD
+ (124*K+tr) 0    (125*K-tr) 0
+ (125*K+tr) VDD  (126*K-tr) VDD
+ (126*K+tr) 0    (127*K-tr) 0
+ (127*K+tr) VDD  (128*K-tr) VDD
+ (128*K+tr) 0    (129*K-tr) 0
+ (129*K+tr) 0    (130*K-tr) 0
+ (130*K+tr) VDD  (131*K-tr) VDD
+ (131*K+tr) 0    (132*K-tr) 0
+ (132*K+tr) VDD  (133*K-tr) VDD
+ (133*K+tr) 0    (134*K-tr) 0
+ (134*K+tr) VDD  (135*K-tr) VDD
+ (135*K+tr) 0    (136*K-tr) 0
+ (136*K+tr) VDD  (137*K-tr) VDD
+ (137*K+tr) 0    (138*K-tr) 0
+ (138*K+tr) 0    (139*K-tr) 0
+ (139*K+tr) VDD  (140*K-tr) VDD
+ (140*K+tr) 0    (141*K-tr) 0
+ (141*K+tr) VDD  (142*K-tr) VDD
+ (142*K+tr) 0    (143*K-tr) 0
+ (143*K+tr) VDD  (144*K-tr) VDD
+ (144*K+tr) 0    (145*K-tr) 0
+ (145*K+tr) VDD  (146*K-tr) VDD
+ (146*K+tr) 0    (147*K-tr) 0
+ (147*K+ 0*L+tr) 0    (147*K+ 1*L-tr) 0
+ (147*K+ 1*L+tr) 0    (147*K+ 2*L-tr) 0
+ (147*K+ 2*L+tr) 0    (147*K+ 3*L-tr) 0
+ (147*K+ 3*L+tr) 0    (147*K+ 4*L-tr) 0
+ (147*K+ 4*L+tr) 0    (147*K+ 5*L-tr) 0
+ (147*K+ 5*L+tr) 0    (147*K+ 6*L-tr) 0
+ (147*K+ 6*L+tr) 0    (147*K+ 7*L-tr) 0
+ (147*K+ 7*L+tr) 0    (147*K+ 8*L-tr) 0
+ (147*K+ 8*L+tr) 0    (147*K+ 9*L-tr) 0
+ (147*K+ 9*L+tr) 0    (147*K+10*L-tr) 0
+ (147*K+10*L+tr) 0    (147*K+11*L-tr) 0
+ (147*K+11*L+tr) 0    (147*K+12*L-tr) 0
+ (147*K+12*L+tr) 0    (147*K+13*L-tr) 0
+ (147*K+13*L+tr) 0    (147*K+14*L-tr) 0
+ ]
vA1 (A1 0) vsource type=pwl wave=\[
+ ( 0*K   ) 0    ( 1*K-tr) 0
+ ( 1*K+tr) 0    ( 2*K-tr) 0
+ ( 2*K+tr) 0    ( 3*K-tr) 0
+ ( 3*K+tr) 0    ( 4*K-tr) 0
+ ( 4*K+tr) 0    ( 5*K-tr) 0
+ ( 5*K+tr) VDD  ( 6*K-tr) VDD
+ ( 6*K+tr) VDD  ( 7*K-tr) VDD
+ ( 7*K+tr) 0    ( 8*K-tr) 0
+ ( 8*K+tr) 0    ( 9*K-tr) 0
+ ( 9*K+tr) VDD  (10*K-tr) VDD
+ (10*K+tr) VDD  (11*K-tr) VDD
+ (11*K+tr) 0    (12*K-tr) 0
+ (12*K+tr) 0    (13*K-tr) 0
+ (13*K+tr) 0    (14*K-tr) 0
+ (14*K+tr) VDD  (15*K-tr) VDD
+ (15*K+tr) VDD  (16*K-tr) VDD
+ (16*K+tr) 0    (17*K-tr) 0
+ (17*K+tr) 0    (18*K-tr) 0
+ (18*K+tr) VDD  (19*K-tr) VDD
+ (19*K+tr) VDD  (20*K-tr) VDD
+ (20*K+tr) 0    (21*K-tr) 0
+ (21*K+tr) 0    (22*K-tr) 0
+ (22*K+tr) 0    (23*K-tr) 0
+ (23*K+tr) VDD  (24*K-tr) VDD
+ (24*K+tr) VDD  (25*K-tr) VDD
+ (25*K+tr) 0    (26*K-tr) 0
+ (26*K+tr) 0    (27*K-tr) 0
+ (27*K+tr) VDD  (28*K-tr) VDD
+ (28*K+tr) VDD  (29*K-tr) VDD
+ (29*K+tr) 0    (30*K-tr) 0
+ (30*K+tr) 0    (31*K-tr) 0
+ (31*K+tr) 0    (32*K-tr) 0
+ (32*K+tr) VDD  (33*K-tr) VDD
+ (33*K+tr) VDD  (34*K-tr) VDD
+ (34*K+tr) 0    (35*K-tr) 0
+ (35*K+tr) 0    (36*K-tr) 0
+ (36*K+tr) VDD  (37*K-tr) VDD
+ (37*K+tr) VDD  (38*K-tr) VDD
+ (38*K+tr) 0    (39*K-tr) 0
+ (39*K+tr) 0    (40*K-tr) 0
+ (40*K+tr) 0    (41*K-tr) 0
+ (41*K+tr) VDD  (42*K-tr) VDD
+ (42*K+tr) VDD  (43*K-tr) VDD
+ (43*K+tr) 0    (44*K-tr) 0
+ (44*K+tr) 0    (45*K-tr) 0
+ (45*K+tr) VDD  (46*K-tr) VDD
+ (46*K+tr) VDD  (47*K-tr) VDD
+ (47*K+tr) 0    (48*K-tr) 0
+ (48*K+tr) 0    (49*K-tr) 0
+ (49*K+tr) 0    (50*K-tr) 0
+ (50*K+tr) VDD  (51*K-tr) VDD
+ (51*K+tr) VDD  (52*K-tr) VDD
+ (52*K+tr) 0    (53*K-tr) 0
+ (53*K+tr) 0    (54*K-tr) 0
+ (54*K+tr) VDD  (55*K-tr) VDD
+ (55*K+tr) VDD  (56*K-tr) VDD
+ (56*K+tr) 0    (57*K-tr) 0
+ (57*K+tr) 0    (58*K-tr) 0
+ (58*K+tr) 0    (59*K-tr) 0
+ (59*K+tr) VDD  (60*K-tr) VDD
+ (60*K+tr) VDD  (61*K-tr) VDD
+ (61*K+tr) 0    (62*K-tr) 0
+ (62*K+tr) 0    (63*K-tr) 0
+ (63*K+tr) VDD  (64*K-tr) VDD
+ (64*K+tr) VDD  (65*K-tr) VDD
+ (65*K+tr) 0    (66*K-tr) 0
+ (66*K+tr) 0    (67*K-tr) 0
+ (67*K+tr) 0    (68*K-tr) 0
+ (68*K+tr) VDD  (69*K-tr) VDD
+ (69*K+tr) VDD  (70*K-tr) VDD
+ (70*K+tr) 0    (71*K-tr) 0
+ (71*K+tr) 0    (72*K-tr) 0
+ (72*K+tr) VDD  (73*K-tr) VDD
+ (73*K+tr) VDD  (74*K-tr) VDD
+ (74*K+tr) 0    (75*K-tr) 0
+ (75*K+tr) 0    (76*K-tr) 0
+ (76*K+tr) 0    (77*K-tr) 0
+ (77*K+tr) VDD  (78*K-tr) VDD
+ (78*K+tr) VDD  (79*K-tr) VDD
+ (79*K+tr) 0    (80*K-tr) 0
+ (80*K+tr) 0    (81*K-tr) 0
+ (81*K+tr) VDD  (82*K-tr) VDD
+ (82*K+tr) VDD  (83*K-tr) VDD
+ (83*K+tr) 0    (84*K-tr) 0
+ (84*K+tr) 0    (85*K-tr) 0
+ (85*K+tr) 0    (86*K-tr) 0
+ (86*K+tr) VDD  (87*K-tr) VDD
+ (87*K+tr) VDD  (88*K-tr) VDD
+ (88*K+tr) 0    (89*K-tr) 0
+ (89*K+tr) 0    (90*K-tr) 0
+ (90*K+tr) VDD  (91*K-tr) VDD
+ (91*K+tr) VDD  (92*K-tr) VDD
+ (92*K+tr) 0    (93*K-tr) 0
+ (93*K+tr) 0    (94*K-tr) 0
+ (94*K+tr) 0    (95*K-tr) 0
+ (95*K+tr) VDD  (96*K-tr) VDD
+ (96*K+tr) VDD  (97*K-tr) VDD
+ (97*K+tr) 0    (98*K-tr) 0
+ (98*K+tr) 0    (99*K-tr) 0
+ (99*K+tr) VDD  (100*K-tr) VDD
+ (100*K+tr) VDD  (101*K-tr) VDD
+ (101*K+tr) 0    (102*K-tr) 0
+ (102*K+tr) 0    (103*K-tr) 0
+ (103*K+tr) 0    (104*K-tr) 0
+ (104*K+tr) VDD  (105*K-tr) VDD
+ (105*K+tr) VDD  (106*K-tr) VDD
+ (106*K+tr) 0    (107*K-tr) 0
+ (107*K+tr) 0    (108*K-tr) 0
+ (108*K+tr) VDD  (109*K-tr) VDD
+ (109*K+tr) VDD  (110*K-tr) VDD
+ (110*K+tr) 0    (111*K-tr) 0
+ (111*K+tr) 0    (112*K-tr) 0
+ (112*K+tr) 0    (113*K-tr) 0
+ (113*K+tr) VDD  (114*K-tr) VDD
+ (114*K+tr) VDD  (115*K-tr) VDD
+ (115*K+tr) 0    (116*K-tr) 0
+ (116*K+tr) 0    (117*K-tr) 0
+ (117*K+tr) VDD  (118*K-tr) VDD
+ (118*K+tr) VDD  (119*K-tr) VDD
+ (119*K+tr) 0    (120*K-tr) 0
+ (120*K+tr) 0    (121*K-tr) 0
+ (121*K+tr) 0    (122*K-tr) 0
+ (122*K+tr) VDD  (123*K-tr) VDD
+ (123*K+tr) VDD  (124*K-tr) VDD
+ (124*K+tr) 0    (125*K-tr) 0
+ (125*K+tr) 0    (126*K-tr) 0
+ (126*K+tr) VDD  (127*K-tr) VDD
+ (127*K+tr) VDD  (128*K-tr) VDD
+ (128*K+tr) 0    (129*K-tr) 0
+ (129*K+tr) 0    (130*K-tr) 0
+ (130*K+tr) 0    (131*K-tr) 0
+ (131*K+tr) VDD  (132*K-tr) VDD
+ (132*K+tr) VDD  (133*K-tr) VDD
+ (133*K+tr) 0    (134*K-tr) 0
+ (134*K+tr) 0    (135*K-tr) 0
+ (135*K+tr) VDD  (136*K-tr) VDD
+ (136*K+tr) VDD  (137*K-tr) VDD
+ (137*K+tr) 0    (138*K-tr) 0
+ (138*K+tr) 0    (139*K-tr) 0
+ (139*K+tr) 0    (140*K-tr) 0
+ (140*K+tr) VDD  (141*K-tr) VDD
+ (141*K+tr) VDD  (142*K-tr) VDD
+ (142*K+tr) 0    (143*K-tr) 0
+ (143*K+tr) 0    (144*K-tr) 0
+ (144*K+tr) VDD  (145*K-tr) VDD
+ (145*K+tr) VDD  (146*K-tr) VDD
+ (146*K+tr) 0    (147*K-tr) 0
+ (147*K+ 0*L+tr) 0    (147*K+ 1*L-tr) 0
+ (147*K+ 1*L+tr) 0    (147*K+ 2*L-tr) 0
+ (147*K+ 2*L+tr) 0    (147*K+ 3*L-tr) 0
+ (147*K+ 3*L+tr) 0    (147*K+ 4*L-tr) 0
+ (147*K+ 4*L+tr) 0    (147*K+ 5*L-tr) 0
+ (147*K+ 5*L+tr) 0    (147*K+ 6*L-tr) 0
+ (147*K+ 6*L+tr) 0    (147*K+ 7*L-tr) 0
+ (147*K+ 7*L+tr) 0    (147*K+ 8*L-tr) 0
+ (147*K+ 8*L+tr) 0    (147*K+ 9*L-tr) 0
+ (147*K+ 9*L+tr) 0    (147*K+10*L-tr) 0
+ (147*K+10*L+tr) 0    (147*K+11*L-tr) 0
+ (147*K+11*L+tr) 0    (147*K+12*L-tr) 0
+ (147*K+12*L+tr) 0    (147*K+13*L-tr) 0
+ (147*K+13*L+tr) 0    (147*K+14*L-tr) 0
+ ]
vA2 (A2 0) vsource type=pwl wave=\[
+ ( 0*K   ) 0    ( 1*K-tr) 0
+ ( 1*K+tr) 0    ( 2*K-tr) 0
+ ( 2*K+tr) 0    ( 3*K-tr) 0
+ ( 3*K+tr) 0    ( 4*K-tr) 0
+ ( 4*K+tr) 0    ( 5*K-tr) 0
+ ( 5*K+tr) 0    ( 6*K-tr) 0
+ ( 6*K+tr) 0    ( 7*K-tr) 0
+ ( 7*K+tr) VDD  ( 8*K-tr) VDD
+ ( 8*K+tr) VDD  ( 9*K-tr) VDD
+ ( 9*K+tr) VDD  (10*K-tr) VDD
+ (10*K+tr) VDD  (11*K-tr) VDD
+ (11*K+tr) 0    (12*K-tr) 0
+ (12*K+tr) 0    (13*K-tr) 0
+ (13*K+tr) 0    (14*K-tr) 0
+ (14*K+tr) 0    (15*K-tr) 0
+ (15*K+tr) 0    (16*K-tr) 0
+ (16*K+tr) VDD  (17*K-tr) VDD
+ (17*K+tr) VDD  (18*K-tr) VDD
+ (18*K+tr) VDD  (19*K-tr) VDD
+ (19*K+tr) VDD  (20*K-tr) VDD
+ (20*K+tr) 0    (21*K-tr) 0
+ (21*K+tr) 0    (22*K-tr) 0
+ (22*K+tr) 0    (23*K-tr) 0
+ (23*K+tr) 0    (24*K-tr) 0
+ (24*K+tr) 0    (25*K-tr) 0
+ (25*K+tr) VDD  (26*K-tr) VDD
+ (26*K+tr) VDD  (27*K-tr) VDD
+ (27*K+tr) VDD  (28*K-tr) VDD
+ (28*K+tr) VDD  (29*K-tr) VDD
+ (29*K+tr) 0    (30*K-tr) 0
+ (30*K+tr) 0    (31*K-tr) 0
+ (31*K+tr) 0    (32*K-tr) 0
+ (32*K+tr) 0    (33*K-tr) 0
+ (33*K+tr) 0    (34*K-tr) 0
+ (34*K+tr) VDD  (35*K-tr) VDD
+ (35*K+tr) VDD  (36*K-tr) VDD
+ (36*K+tr) VDD  (37*K-tr) VDD
+ (37*K+tr) VDD  (38*K-tr) VDD
+ (38*K+tr) 0    (39*K-tr) 0
+ (39*K+tr) 0    (40*K-tr) 0
+ (40*K+tr) 0    (41*K-tr) 0
+ (41*K+tr) 0    (42*K-tr) 0
+ (42*K+tr) 0    (43*K-tr) 0
+ (43*K+tr) VDD  (44*K-tr) VDD
+ (44*K+tr) VDD  (45*K-tr) VDD
+ (45*K+tr) VDD  (46*K-tr) VDD
+ (46*K+tr) VDD  (47*K-tr) VDD
+ (47*K+tr) 0    (48*K-tr) 0
+ (48*K+tr) 0    (49*K-tr) 0
+ (49*K+tr) 0    (50*K-tr) 0
+ (50*K+tr) 0    (51*K-tr) 0
+ (51*K+tr) 0    (52*K-tr) 0
+ (52*K+tr) VDD  (53*K-tr) VDD
+ (53*K+tr) VDD  (54*K-tr) VDD
+ (54*K+tr) VDD  (55*K-tr) VDD
+ (55*K+tr) VDD  (56*K-tr) VDD
+ (56*K+tr) 0    (57*K-tr) 0
+ (57*K+tr) 0    (58*K-tr) 0
+ (58*K+tr) 0    (59*K-tr) 0
+ (59*K+tr) 0    (60*K-tr) 0
+ (60*K+tr) 0    (61*K-tr) 0
+ (61*K+tr) VDD  (62*K-tr) VDD
+ (62*K+tr) VDD  (63*K-tr) VDD
+ (63*K+tr) VDD  (64*K-tr) VDD
+ (64*K+tr) VDD  (65*K-tr) VDD
+ (65*K+tr) 0    (66*K-tr) 0
+ (66*K+tr) 0    (67*K-tr) 0
+ (67*K+tr) 0    (68*K-tr) 0
+ (68*K+tr) 0    (69*K-tr) 0
+ (69*K+tr) 0    (70*K-tr) 0
+ (70*K+tr) VDD  (71*K-tr) VDD
+ (71*K+tr) VDD  (72*K-tr) VDD
+ (72*K+tr) VDD  (73*K-tr) VDD
+ (73*K+tr) VDD  (74*K-tr) VDD
+ (74*K+tr) 0    (75*K-tr) 0
+ (75*K+tr) 0    (76*K-tr) 0
+ (76*K+tr) 0    (77*K-tr) 0
+ (77*K+tr) 0    (78*K-tr) 0
+ (78*K+tr) 0    (79*K-tr) 0
+ (79*K+tr) VDD  (80*K-tr) VDD
+ (80*K+tr) VDD  (81*K-tr) VDD
+ (81*K+tr) VDD  (82*K-tr) VDD
+ (82*K+tr) VDD  (83*K-tr) VDD
+ (83*K+tr) 0    (84*K-tr) 0
+ (84*K+tr) 0    (85*K-tr) 0
+ (85*K+tr) 0    (86*K-tr) 0
+ (86*K+tr) 0    (87*K-tr) 0
+ (87*K+tr) 0    (88*K-tr) 0
+ (88*K+tr) VDD  (89*K-tr) VDD
+ (89*K+tr) VDD  (90*K-tr) VDD
+ (90*K+tr) VDD  (91*K-tr) VDD
+ (91*K+tr) VDD  (92*K-tr) VDD
+ (92*K+tr) 0    (93*K-tr) 0
+ (93*K+tr) 0    (94*K-tr) 0
+ (94*K+tr) 0    (95*K-tr) 0
+ (95*K+tr) 0    (96*K-tr) 0
+ (96*K+tr) 0    (97*K-tr) 0
+ (97*K+tr) VDD  (98*K-tr) VDD
+ (98*K+tr) VDD  (99*K-tr) VDD
+ (99*K+tr) VDD  (100*K-tr) VDD
+ (100*K+tr) VDD  (101*K-tr) VDD
+ (101*K+tr) 0    (102*K-tr) 0
+ (102*K+tr) 0    (103*K-tr) 0
+ (103*K+tr) 0    (104*K-tr) 0
+ (104*K+tr) 0    (105*K-tr) 0
+ (105*K+tr) 0    (106*K-tr) 0
+ (106*K+tr) VDD  (107*K-tr) VDD
+ (107*K+tr) VDD  (108*K-tr) VDD
+ (108*K+tr) VDD  (109*K-tr) VDD
+ (109*K+tr) VDD  (110*K-tr) VDD
+ (110*K+tr) 0    (111*K-tr) 0
+ (111*K+tr) 0    (112*K-tr) 0
+ (112*K+tr) 0    (113*K-tr) 0
+ (113*K+tr) 0    (114*K-tr) 0
+ (114*K+tr) 0    (115*K-tr) 0
+ (115*K+tr) VDD  (116*K-tr) VDD
+ (116*K+tr) VDD  (117*K-tr) VDD
+ (117*K+tr) VDD  (118*K-tr) VDD
+ (118*K+tr) VDD  (119*K-tr) VDD
+ (119*K+tr) 0    (120*K-tr) 0
+ (120*K+tr) 0    (121*K-tr) 0
+ (121*K+tr) 0    (122*K-tr) 0
+ (122*K+tr) 0    (123*K-tr) 0
+ (123*K+tr) 0    (124*K-tr) 0
+ (124*K+tr) VDD  (125*K-tr) VDD
+ (125*K+tr) VDD  (126*K-tr) VDD
+ (126*K+tr) VDD  (127*K-tr) VDD
+ (127*K+tr) VDD  (128*K-tr) VDD
+ (128*K+tr) 0    (129*K-tr) 0
+ (129*K+tr) 0    (130*K-tr) 0
+ (130*K+tr) 0    (131*K-tr) 0
+ (131*K+tr) 0    (132*K-tr) 0
+ (132*K+tr) 0    (133*K-tr) 0
+ (133*K+tr) VDD  (134*K-tr) VDD
+ (134*K+tr) VDD  (135*K-tr) VDD
+ (135*K+tr) VDD  (136*K-tr) VDD
+ (136*K+tr) VDD  (137*K-tr) VDD
+ (137*K+tr) 0    (138*K-tr) 0
+ (138*K+tr) 0    (139*K-tr) 0
+ (139*K+tr) 0    (140*K-tr) 0
+ (140*K+tr) 0    (141*K-tr) 0
+ (141*K+tr) 0    (142*K-tr) 0
+ (142*K+tr) VDD  (143*K-tr) VDD
+ (143*K+tr) VDD  (144*K-tr) VDD
+ (144*K+tr) VDD  (145*K-tr) VDD
+ (145*K+tr) VDD  (146*K-tr) VDD
+ (146*K+tr) 0    (147*K-tr) 0
+ (147*K+ 0*L+tr) 0    (147*K+ 1*L-tr) 0
+ (147*K+ 1*L+tr) 0    (147*K+ 2*L-tr) 0
+ (147*K+ 2*L+tr) 0    (147*K+ 3*L-tr) 0
+ (147*K+ 3*L+tr) 0    (147*K+ 4*L-tr) 0
+ (147*K+ 4*L+tr) 0    (147*K+ 5*L-tr) 0
+ (147*K+ 5*L+tr) 0    (147*K+ 6*L-tr) 0
+ (147*K+ 6*L+tr) 0    (147*K+ 7*L-tr) 0
+ (147*K+ 7*L+tr) 0    (147*K+ 8*L-tr) 0
+ (147*K+ 8*L+tr) 0    (147*K+ 9*L-tr) 0
+ (147*K+ 9*L+tr) 0    (147*K+10*L-tr) 0
+ (147*K+10*L+tr) 0    (147*K+11*L-tr) 0
+ (147*K+11*L+tr) 0    (147*K+12*L-tr) 0
+ (147*K+12*L+tr) 0    (147*K+13*L-tr) 0
+ (147*K+13*L+tr) 0    (147*K+14*L-tr) 0
+ ]
vA3 (A3 0) vsource type=pwl wave=\[
+ ( 0*K   ) 0    ( 1*K-tr) 0
+ ( 1*K+tr) 0    ( 2*K-tr) 0
+ ( 2*K+tr) 0    ( 3*K-tr) 0
+ ( 3*K+tr) 0    ( 4*K-tr) 0
+ ( 4*K+tr) 0    ( 5*K-tr) 0
+ ( 5*K+tr) 0    ( 6*K-tr) 0
+ ( 6*K+tr) 0    ( 7*K-tr) 0
+ ( 7*K+tr) 0    ( 8*K-tr) 0
+ ( 8*K+tr) 0    ( 9*K-tr) 0
+ ( 9*K+tr) 0    (10*K-tr) 0
+ (10*K+tr) 0    (11*K-tr) 0
+ (11*K+tr) VDD  (12*K-tr) VDD
+ (12*K+tr) 0    (13*K-tr) 0
+ (13*K+tr) 0    (14*K-tr) 0
+ (14*K+tr) 0    (15*K-tr) 0
+ (15*K+tr) 0    (16*K-tr) 0
+ (16*K+tr) 0    (17*K-tr) 0
+ (17*K+tr) 0    (18*K-tr) 0
+ (18*K+tr) 0    (19*K-tr) 0
+ (19*K+tr) 0    (20*K-tr) 0
+ (20*K+tr) VDD  (21*K-tr) VDD
+ (21*K+tr) 0    (22*K-tr) 0
+ (22*K+tr) 0    (23*K-tr) 0
+ (23*K+tr) 0    (24*K-tr) 0
+ (24*K+tr) 0    (25*K-tr) 0
+ (25*K+tr) 0    (26*K-tr) 0
+ (26*K+tr) 0    (27*K-tr) 0
+ (27*K+tr) 0    (28*K-tr) 0
+ (28*K+tr) 0    (29*K-tr) 0
+ (29*K+tr) VDD  (30*K-tr) VDD
+ (30*K+tr) 0    (31*K-tr) 0
+ (31*K+tr) 0    (32*K-tr) 0
+ (32*K+tr) 0    (33*K-tr) 0
+ (33*K+tr) 0    (34*K-tr) 0
+ (34*K+tr) 0    (35*K-tr) 0
+ (35*K+tr) 0    (36*K-tr) 0
+ (36*K+tr) 0    (37*K-tr) 0
+ (37*K+tr) 0    (38*K-tr) 0
+ (38*K+tr) VDD  (39*K-tr) VDD
+ (39*K+tr) 0    (40*K-tr) 0
+ (40*K+tr) 0    (41*K-tr) 0
+ (41*K+tr) 0    (42*K-tr) 0
+ (42*K+tr) 0    (43*K-tr) 0
+ (43*K+tr) 0    (44*K-tr) 0
+ (44*K+tr) 0    (45*K-tr) 0
+ (45*K+tr) 0    (46*K-tr) 0
+ (46*K+tr) 0    (47*K-tr) 0
+ (47*K+tr) VDD  (48*K-tr) VDD
+ (48*K+tr) 0    (49*K-tr) 0
+ (49*K+tr) 0    (50*K-tr) 0
+ (50*K+tr) 0    (51*K-tr) 0
+ (51*K+tr) 0    (52*K-tr) 0
+ (52*K+tr) 0    (53*K-tr) 0
+ (53*K+tr) 0    (54*K-tr) 0
+ (54*K+tr) 0    (55*K-tr) 0
+ (55*K+tr) 0    (56*K-tr) 0
+ (56*K+tr) VDD  (57*K-tr) VDD
+ (57*K+tr) 0    (58*K-tr) 0
+ (58*K+tr) 0    (59*K-tr) 0
+ (59*K+tr) 0    (60*K-tr) 0
+ (60*K+tr) 0    (61*K-tr) 0
+ (61*K+tr) 0    (62*K-tr) 0
+ (62*K+tr) 0    (63*K-tr) 0
+ (63*K+tr) 0    (64*K-tr) 0
+ (64*K+tr) 0    (65*K-tr) 0
+ (65*K+tr) VDD  (66*K-tr) VDD
+ (66*K+tr) 0    (67*K-tr) 0
+ (67*K+tr) 0    (68*K-tr) 0
+ (68*K+tr) 0    (69*K-tr) 0
+ (69*K+tr) 0    (70*K-tr) 0
+ (70*K+tr) 0    (71*K-tr) 0
+ (71*K+tr) 0    (72*K-tr) 0
+ (72*K+tr) 0    (73*K-tr) 0
+ (73*K+tr) 0    (74*K-tr) 0
+ (74*K+tr) VDD  (75*K-tr) VDD
+ (75*K+tr) 0    (76*K-tr) 0
+ (76*K+tr) 0    (77*K-tr) 0
+ (77*K+tr) 0    (78*K-tr) 0
+ (78*K+tr) 0    (79*K-tr) 0
+ (79*K+tr) 0    (80*K-tr) 0
+ (80*K+tr) 0    (81*K-tr) 0
+ (81*K+tr) 0    (82*K-tr) 0
+ (82*K+tr) 0    (83*K-tr) 0
+ (83*K+tr) VDD  (84*K-tr) VDD
+ (84*K+tr) 0    (85*K-tr) 0
+ (85*K+tr) 0    (86*K-tr) 0
+ (86*K+tr) 0    (87*K-tr) 0
+ (87*K+tr) 0    (88*K-tr) 0
+ (88*K+tr) 0    (89*K-tr) 0
+ (89*K+tr) 0    (90*K-tr) 0
+ (90*K+tr) 0    (91*K-tr) 0
+ (91*K+tr) 0    (92*K-tr) 0
+ (92*K+tr) VDD  (93*K-tr) VDD
+ (93*K+tr) 0    (94*K-tr) 0
+ (94*K+tr) 0    (95*K-tr) 0
+ (95*K+tr) 0    (96*K-tr) 0
+ (96*K+tr) 0    (97*K-tr) 0
+ (97*K+tr) 0    (98*K-tr) 0
+ (98*K+tr) 0    (99*K-tr) 0
+ (99*K+tr) 0    (100*K-tr) 0
+ (100*K+tr) 0    (101*K-tr) 0
+ (101*K+tr) VDD  (102*K-tr) VDD
+ (102*K+tr) 0    (103*K-tr) 0
+ (103*K+tr) 0    (104*K-tr) 0
+ (104*K+tr) 0    (105*K-tr) 0
+ (105*K+tr) 0    (106*K-tr) 0
+ (106*K+tr) 0    (107*K-tr) 0
+ (107*K+tr) 0    (108*K-tr) 0
+ (108*K+tr) 0    (109*K-tr) 0
+ (109*K+tr) 0    (110*K-tr) 0
+ (110*K+tr) VDD  (111*K-tr) VDD
+ (111*K+tr) 0    (112*K-tr) 0
+ (112*K+tr) 0    (113*K-tr) 0
+ (113*K+tr) 0    (114*K-tr) 0
+ (114*K+tr) 0    (115*K-tr) 0
+ (115*K+tr) 0    (116*K-tr) 0
+ (116*K+tr) 0    (117*K-tr) 0
+ (117*K+tr) 0    (118*K-tr) 0
+ (118*K+tr) 0    (119*K-tr) 0
+ (119*K+tr) VDD  (120*K-tr) VDD
+ (120*K+tr) 0    (121*K-tr) 0
+ (121*K+tr) 0    (122*K-tr) 0
+ (122*K+tr) 0    (123*K-tr) 0
+ (123*K+tr) 0    (124*K-tr) 0
+ (124*K+tr) 0    (125*K-tr) 0
+ (125*K+tr) 0    (126*K-tr) 0
+ (126*K+tr) 0    (127*K-tr) 0
+ (127*K+tr) 0    (128*K-tr) 0
+ (128*K+tr) VDD  (129*K-tr) VDD
+ (129*K+tr) 0    (130*K-tr) 0
+ (130*K+tr) 0    (131*K-tr) 0
+ (131*K+tr) 0    (132*K-tr) 0
+ (132*K+tr) 0    (133*K-tr) 0
+ (133*K+tr) 0    (134*K-tr) 0
+ (134*K+tr) 0    (135*K-tr) 0
+ (135*K+tr) 0    (136*K-tr) 0
+ (136*K+tr) 0    (137*K-tr) 0
+ (137*K+tr) VDD  (138*K-tr) VDD
+ (138*K+tr) 0    (139*K-tr) 0
+ (139*K+tr) 0    (140*K-tr) 0
+ (140*K+tr) 0    (141*K-tr) 0
+ (141*K+tr) 0    (142*K-tr) 0
+ (142*K+tr) 0    (143*K-tr) 0
+ (143*K+tr) 0    (144*K-tr) 0
+ (144*K+tr) 0    (145*K-tr) 0
+ (145*K+tr) 0    (146*K-tr) 0
+ (146*K+tr) VDD  (147*K-tr) VDD
+ (147*K+ 0*L+tr) 0    (147*K+ 1*L-tr) 0
+ (147*K+ 1*L+tr) 0    (147*K+ 2*L-tr) 0
+ (147*K+ 2*L+tr) 0    (147*K+ 3*L-tr) 0
+ (147*K+ 3*L+tr) 0    (147*K+ 4*L-tr) 0
+ (147*K+ 4*L+tr) 0    (147*K+ 5*L-tr) 0
+ (147*K+ 5*L+tr) 0    (147*K+ 6*L-tr) 0
+ (147*K+ 6*L+tr) 0    (147*K+ 7*L-tr) 0
+ (147*K+ 7*L+tr) 0    (147*K+ 8*L-tr) 0
+ (147*K+ 8*L+tr) 0    (147*K+ 9*L-tr) 0
+ (147*K+ 9*L+tr) 0    (147*K+10*L-tr) 0
+ (147*K+10*L+tr) 0    (147*K+11*L-tr) 0
+ (147*K+11*L+tr) 0    (147*K+12*L-tr) 0
+ (147*K+12*L+tr) 0    (147*K+13*L-tr) 0
+ (147*K+13*L+tr) 0    (147*K+14*L-tr) 0
+ ]
vA4 (A4 0) vsource type=pwl wave=\[
+ ( 0*K   ) 0    ( 1*K-tr) 0
+ ( 1*K+tr) 0    ( 2*K-tr) 0
+ ( 2*K+tr) 0    ( 3*K-tr) 0
+ ( 3*K+tr) 0    ( 4*K-tr) 0
+ ( 4*K+tr) 0    ( 5*K-tr) 0
+ ( 5*K+tr) 0    ( 6*K-tr) 0
+ ( 6*K+tr) 0    ( 7*K-tr) 0
+ ( 7*K+tr) 0    ( 8*K-tr) 0
+ ( 8*K+tr) 0    ( 9*K-tr) 0
+ ( 9*K+tr) 0    (10*K-tr) 0
+ (10*K+tr) 0    (11*K-tr) 0
+ (11*K+tr) 0    (12*K-tr) 0
+ (12*K+tr) 0    (13*K-tr) 0
+ (13*K+tr) 0    (14*K-tr) 0
+ (14*K+tr) 0    (15*K-tr) 0
+ (15*K+tr) 0    (16*K-tr) 0
+ (16*K+tr) 0    (17*K-tr) 0
+ (17*K+tr) 0    (18*K-tr) 0
+ (18*K+tr) 0    (19*K-tr) 0
+ (19*K+tr) 0    (20*K-tr) 0
+ (20*K+tr) 0    (21*K-tr) 0
+ (21*K+tr) 0    (22*K-tr) 0
+ (22*K+tr) 0    (23*K-tr) 0
+ (23*K+tr) 0    (24*K-tr) 0
+ (24*K+tr) 0    (25*K-tr) 0
+ (25*K+tr) 0    (26*K-tr) 0
+ (26*K+tr) 0    (27*K-tr) 0
+ (27*K+tr) 0    (28*K-tr) 0
+ (28*K+tr) 0    (29*K-tr) 0
+ (29*K+tr) 0    (30*K-tr) 0
+ (30*K+tr) 0    (31*K-tr) 0
+ (31*K+tr) 0    (32*K-tr) 0
+ (32*K+tr) 0    (33*K-tr) 0
+ (33*K+tr) 0    (34*K-tr) 0
+ (34*K+tr) 0    (35*K-tr) 0
+ (35*K+tr) 0    (36*K-tr) 0
+ (36*K+tr) 0    (37*K-tr) 0
+ (37*K+tr) 0    (38*K-tr) 0
+ (38*K+tr) 0    (39*K-tr) 0
+ (39*K+tr) 0    (40*K-tr) 0
+ (40*K+tr) 0    (41*K-tr) 0
+ (41*K+tr) 0    (42*K-tr) 0
+ (42*K+tr) 0    (43*K-tr) 0
+ (43*K+tr) 0    (44*K-tr) 0
+ (44*K+tr) 0    (45*K-tr) 0
+ (45*K+tr) 0    (46*K-tr) 0
+ (46*K+tr) 0    (47*K-tr) 0
+ (47*K+tr) 0    (48*K-tr) 0
+ (48*K+tr) 0    (49*K-tr) 0
+ (49*K+tr) 0    (50*K-tr) 0
+ (50*K+tr) 0    (51*K-tr) 0
+ (51*K+tr) 0    (52*K-tr) 0
+ (52*K+tr) 0    (53*K-tr) 0
+ (53*K+tr) 0    (54*K-tr) 0
+ (54*K+tr) 0    (55*K-tr) 0
+ (55*K+tr) 0    (56*K-tr) 0
+ (56*K+tr) 0    (57*K-tr) 0
+ (57*K+tr) 0    (58*K-tr) 0
+ (58*K+tr) 0    (59*K-tr) 0
+ (59*K+tr) 0    (60*K-tr) 0
+ (60*K+tr) 0    (61*K-tr) 0
+ (61*K+tr) 0    (62*K-tr) 0
+ (62*K+tr) 0    (63*K-tr) 0
+ (63*K+tr) 0    (64*K-tr) 0
+ (64*K+tr) 0    (65*K-tr) 0
+ (65*K+tr) 0    (66*K-tr) 0
+ (66*K+tr) 0    (67*K-tr) 0
+ (67*K+tr) 0    (68*K-tr) 0
+ (68*K+tr) 0    (69*K-tr) 0
+ (69*K+tr) 0    (70*K-tr) 0
+ (70*K+tr) 0    (71*K-tr) 0
+ (71*K+tr) 0    (72*K-tr) 0
+ (72*K+tr) 0    (73*K-tr) 0
+ (73*K+tr) 0    (74*K-tr) 0
+ (74*K+tr) 0    (75*K-tr) 0
+ (75*K+tr) 0    (76*K-tr) 0
+ (76*K+tr) 0    (77*K-tr) 0
+ (77*K+tr) 0    (78*K-tr) 0
+ (78*K+tr) 0    (79*K-tr) 0
+ (79*K+tr) 0    (80*K-tr) 0
+ (80*K+tr) 0    (81*K-tr) 0
+ (81*K+tr) 0    (82*K-tr) 0
+ (82*K+tr) 0    (83*K-tr) 0
+ (83*K+tr) 0    (84*K-tr) 0
+ (84*K+tr) 0    (85*K-tr) 0
+ (85*K+tr) 0    (86*K-tr) 0
+ (86*K+tr) 0    (87*K-tr) 0
+ (87*K+tr) 0    (88*K-tr) 0
+ (88*K+tr) 0    (89*K-tr) 0
+ (89*K+tr) 0    (90*K-tr) 0
+ (90*K+tr) 0    (91*K-tr) 0
+ (91*K+tr) 0    (92*K-tr) 0
+ (92*K+tr) 0    (93*K-tr) 0
+ (93*K+tr) 0    (94*K-tr) 0
+ (94*K+tr) 0    (95*K-tr) 0
+ (95*K+tr) 0    (96*K-tr) 0
+ (96*K+tr) 0    (97*K-tr) 0
+ (97*K+tr) 0    (98*K-tr) 0
+ (98*K+tr) 0    (99*K-tr) 0
+ (99*K+tr) 0    (100*K-tr) 0
+ (100*K+tr) 0    (101*K-tr) 0
+ (101*K+tr) 0    (102*K-tr) 0
+ (102*K+tr) 0    (103*K-tr) 0
+ (103*K+tr) 0    (104*K-tr) 0
+ (104*K+tr) 0    (105*K-tr) 0
+ (105*K+tr) 0    (106*K-tr) 0
+ (106*K+tr) 0    (107*K-tr) 0
+ (107*K+tr) 0    (108*K-tr) 0
+ (108*K+tr) 0    (109*K-tr) 0
+ (109*K+tr) 0    (110*K-tr) 0
+ (110*K+tr) 0    (111*K-tr) 0
+ (111*K+tr) 0    (112*K-tr) 0
+ (112*K+tr) 0    (113*K-tr) 0
+ (113*K+tr) 0    (114*K-tr) 0
+ (114*K+tr) 0    (115*K-tr) 0
+ (115*K+tr) 0    (116*K-tr) 0
+ (116*K+tr) 0    (117*K-tr) 0
+ (117*K+tr) 0    (118*K-tr) 0
+ (118*K+tr) 0    (119*K-tr) 0
+ (119*K+tr) 0    (120*K-tr) 0
+ (120*K+tr) 0    (121*K-tr) 0
+ (121*K+tr) 0    (122*K-tr) 0
+ (122*K+tr) 0    (123*K-tr) 0
+ (123*K+tr) 0    (124*K-tr) 0
+ (124*K+tr) 0    (125*K-tr) 0
+ (125*K+tr) 0    (126*K-tr) 0
+ (126*K+tr) 0    (127*K-tr) 0
+ (127*K+tr) 0    (128*K-tr) 0
+ (128*K+tr) 0    (129*K-tr) 0
+ (129*K+tr) 0    (130*K-tr) 0
+ (130*K+tr) 0    (131*K-tr) 0
+ (131*K+tr) 0    (132*K-tr) 0
+ (132*K+tr) 0    (133*K-tr) 0
+ (133*K+tr) 0    (134*K-tr) 0
+ (134*K+tr) 0    (135*K-tr) 0
+ (135*K+tr) 0    (136*K-tr) 0
+ (136*K+tr) 0    (137*K-tr) 0
+ (137*K+tr) 0    (138*K-tr) 0
+ (138*K+tr) 0    (139*K-tr) 0
+ (139*K+tr) 0    (140*K-tr) 0
+ (140*K+tr) 0    (141*K-tr) 0
+ (141*K+tr) 0    (142*K-tr) 0
+ (142*K+tr) 0    (143*K-tr) 0
+ (143*K+tr) 0    (144*K-tr) 0
+ (144*K+tr) 0    (145*K-tr) 0
+ (145*K+tr) 0    (146*K-tr) 0
+ (146*K+tr) 0    (147*K-tr) 0
+ (147*K+ 0*L+tr) 0    (147*K+ 1*L-tr) 0
+ (147*K+ 1*L+tr) 0    (147*K+ 2*L-tr) 0
+ (147*K+ 2*L+tr) 0    (147*K+ 3*L-tr) 0
+ (147*K+ 3*L+tr) 0    (147*K+ 4*L-tr) 0
+ (147*K+ 4*L+tr) 0    (147*K+ 5*L-tr) 0
+ (147*K+ 5*L+tr) 0    (147*K+ 6*L-tr) 0
+ (147*K+ 6*L+tr) 0    (147*K+ 7*L-tr) 0
+ (147*K+ 7*L+tr) 0    (147*K+ 8*L-tr) 0
+ (147*K+ 8*L+tr) 0    (147*K+ 9*L-tr) 0
+ (147*K+ 9*L+tr) 0    (147*K+10*L-tr) 0
+ (147*K+10*L+tr) 0    (147*K+11*L-tr) 0
+ (147*K+11*L+tr) 0    (147*K+12*L-tr) 0
+ (147*K+12*L+tr) 0    (147*K+13*L-tr) 0
+ (147*K+13*L+tr) 0    (147*K+14*L-tr) 0
+ ]
vA5 (A5 0) vsource type=pwl wave=\[
+ ( 0*K   ) 0    ( 1*K-tr) 0
+ ( 1*K+tr) 0    ( 2*K-tr) 0
+ ( 2*K+tr) 0    ( 3*K-tr) 0
+ ( 3*K+tr) 0    ( 4*K-tr) 0
+ ( 4*K+tr) 0    ( 5*K-tr) 0
+ ( 5*K+tr) 0    ( 6*K-tr) 0
+ ( 6*K+tr) 0    ( 7*K-tr) 0
+ ( 7*K+tr) 0    ( 8*K-tr) 0
+ ( 8*K+tr) 0    ( 9*K-tr) 0
+ ( 9*K+tr) 0    (10*K-tr) 0
+ (10*K+tr) 0    (11*K-tr) 0
+ (11*K+tr) 0    (12*K-tr) 0
+ (12*K+tr) VDD  (13*K-tr) VDD
+ (13*K+tr) VDD  (14*K-tr) VDD
+ (14*K+tr) VDD  (15*K-tr) VDD
+ (15*K+tr) VDD  (16*K-tr) VDD
+ (16*K+tr) VDD  (17*K-tr) VDD
+ (17*K+tr) VDD  (18*K-tr) VDD
+ (18*K+tr) VDD  (19*K-tr) VDD
+ (19*K+tr) VDD  (20*K-tr) VDD
+ (20*K+tr) VDD  (21*K-tr) VDD
+ (21*K+tr) 0    (22*K-tr) 0
+ (22*K+tr) 0    (23*K-tr) 0
+ (23*K+tr) 0    (24*K-tr) 0
+ (24*K+tr) 0    (25*K-tr) 0
+ (25*K+tr) 0    (26*K-tr) 0
+ (26*K+tr) 0    (27*K-tr) 0
+ (27*K+tr) 0    (28*K-tr) 0
+ (28*K+tr) 0    (29*K-tr) 0
+ (29*K+tr) 0    (30*K-tr) 0
+ (30*K+tr) VDD  (31*K-tr) VDD
+ (31*K+tr) VDD  (32*K-tr) VDD
+ (32*K+tr) VDD  (33*K-tr) VDD
+ (33*K+tr) VDD  (34*K-tr) VDD
+ (34*K+tr) VDD  (35*K-tr) VDD
+ (35*K+tr) VDD  (36*K-tr) VDD
+ (36*K+tr) VDD  (37*K-tr) VDD
+ (37*K+tr) VDD  (38*K-tr) VDD
+ (38*K+tr) VDD  (39*K-tr) VDD
+ (39*K+tr) 0    (40*K-tr) 0
+ (40*K+tr) 0    (41*K-tr) 0
+ (41*K+tr) 0    (42*K-tr) 0
+ (42*K+tr) 0    (43*K-tr) 0
+ (43*K+tr) 0    (44*K-tr) 0
+ (44*K+tr) 0    (45*K-tr) 0
+ (45*K+tr) 0    (46*K-tr) 0
+ (46*K+tr) 0    (47*K-tr) 0
+ (47*K+tr) 0    (48*K-tr) 0
+ (48*K+tr) VDD  (49*K-tr) VDD
+ (49*K+tr) VDD  (50*K-tr) VDD
+ (50*K+tr) VDD  (51*K-tr) VDD
+ (51*K+tr) VDD  (52*K-tr) VDD
+ (52*K+tr) VDD  (53*K-tr) VDD
+ (53*K+tr) VDD  (54*K-tr) VDD
+ (54*K+tr) VDD  (55*K-tr) VDD
+ (55*K+tr) VDD  (56*K-tr) VDD
+ (56*K+tr) VDD  (57*K-tr) VDD
+ (57*K+tr) 0    (58*K-tr) 0
+ (58*K+tr) 0    (59*K-tr) 0
+ (59*K+tr) 0    (60*K-tr) 0
+ (60*K+tr) 0    (61*K-tr) 0
+ (61*K+tr) 0    (62*K-tr) 0
+ (62*K+tr) 0    (63*K-tr) 0
+ (63*K+tr) 0    (64*K-tr) 0
+ (64*K+tr) 0    (65*K-tr) 0
+ (65*K+tr) 0    (66*K-tr) 0
+ (66*K+tr) VDD  (67*K-tr) VDD
+ (67*K+tr) VDD  (68*K-tr) VDD
+ (68*K+tr) VDD  (69*K-tr) VDD
+ (69*K+tr) VDD  (70*K-tr) VDD
+ (70*K+tr) VDD  (71*K-tr) VDD
+ (71*K+tr) VDD  (72*K-tr) VDD
+ (72*K+tr) VDD  (73*K-tr) VDD
+ (73*K+tr) VDD  (74*K-tr) VDD
+ (74*K+tr) VDD  (75*K-tr) VDD
+ (75*K+tr) 0    (76*K-tr) 0
+ (76*K+tr) 0    (77*K-tr) 0
+ (77*K+tr) 0    (78*K-tr) 0
+ (78*K+tr) 0    (79*K-tr) 0
+ (79*K+tr) 0    (80*K-tr) 0
+ (80*K+tr) 0    (81*K-tr) 0
+ (81*K+tr) 0    (82*K-tr) 0
+ (82*K+tr) 0    (83*K-tr) 0
+ (83*K+tr) 0    (84*K-tr) 0
+ (84*K+tr) VDD  (85*K-tr) VDD
+ (85*K+tr) VDD  (86*K-tr) VDD
+ (86*K+tr) VDD  (87*K-tr) VDD
+ (87*K+tr) VDD  (88*K-tr) VDD
+ (88*K+tr) VDD  (89*K-tr) VDD
+ (89*K+tr) VDD  (90*K-tr) VDD
+ (90*K+tr) VDD  (91*K-tr) VDD
+ (91*K+tr) VDD  (92*K-tr) VDD
+ (92*K+tr) VDD  (93*K-tr) VDD
+ (93*K+tr) 0    (94*K-tr) 0
+ (94*K+tr) 0    (95*K-tr) 0
+ (95*K+tr) 0    (96*K-tr) 0
+ (96*K+tr) 0    (97*K-tr) 0
+ (97*K+tr) 0    (98*K-tr) 0
+ (98*K+tr) 0    (99*K-tr) 0
+ (99*K+tr) 0    (100*K-tr) 0
+ (100*K+tr) 0    (101*K-tr) 0
+ (101*K+tr) 0    (102*K-tr) 0
+ (102*K+tr) VDD  (103*K-tr) VDD
+ (103*K+tr) VDD  (104*K-tr) VDD
+ (104*K+tr) VDD  (105*K-tr) VDD
+ (105*K+tr) VDD  (106*K-tr) VDD
+ (106*K+tr) VDD  (107*K-tr) VDD
+ (107*K+tr) VDD  (108*K-tr) VDD
+ (108*K+tr) VDD  (109*K-tr) VDD
+ (109*K+tr) VDD  (110*K-tr) VDD
+ (110*K+tr) VDD  (111*K-tr) VDD
+ (111*K+tr) 0    (112*K-tr) 0
+ (112*K+tr) 0    (113*K-tr) 0
+ (113*K+tr) 0    (114*K-tr) 0
+ (114*K+tr) 0    (115*K-tr) 0
+ (115*K+tr) 0    (116*K-tr) 0
+ (116*K+tr) 0    (117*K-tr) 0
+ (117*K+tr) 0    (118*K-tr) 0
+ (118*K+tr) 0    (119*K-tr) 0
+ (119*K+tr) 0    (120*K-tr) 0
+ (120*K+tr) VDD  (121*K-tr) VDD
+ (121*K+tr) VDD  (122*K-tr) VDD
+ (122*K+tr) VDD  (123*K-tr) VDD
+ (123*K+tr) VDD  (124*K-tr) VDD
+ (124*K+tr) VDD  (125*K-tr) VDD
+ (125*K+tr) VDD  (126*K-tr) VDD
+ (126*K+tr) VDD  (127*K-tr) VDD
+ (127*K+tr) VDD  (128*K-tr) VDD
+ (128*K+tr) VDD  (129*K-tr) VDD
+ (129*K+tr) 0    (130*K-tr) 0
+ (130*K+tr) 0    (131*K-tr) 0
+ (131*K+tr) 0    (132*K-tr) 0
+ (132*K+tr) 0    (133*K-tr) 0
+ (133*K+tr) 0    (134*K-tr) 0
+ (134*K+tr) 0    (135*K-tr) 0
+ (135*K+tr) 0    (136*K-tr) 0
+ (136*K+tr) 0    (137*K-tr) 0
+ (137*K+tr) 0    (138*K-tr) 0
+ (138*K+tr) VDD  (139*K-tr) VDD
+ (139*K+tr) VDD  (140*K-tr) VDD
+ (140*K+tr) VDD  (141*K-tr) VDD
+ (141*K+tr) VDD  (142*K-tr) VDD
+ (142*K+tr) VDD  (143*K-tr) VDD
+ (143*K+tr) VDD  (144*K-tr) VDD
+ (144*K+tr) VDD  (145*K-tr) VDD
+ (145*K+tr) VDD  (146*K-tr) VDD
+ (146*K+tr) VDD  (147*K-tr) VDD
+ (147*K+ 0*L+tr) 0    (147*K+ 1*L-tr) 0
+ (147*K+ 1*L+tr) 0    (147*K+ 2*L-tr) 0
+ (147*K+ 2*L+tr) 0    (147*K+ 3*L-tr) 0
+ (147*K+ 3*L+tr) 0    (147*K+ 4*L-tr) 0
+ (147*K+ 4*L+tr) 0    (147*K+ 5*L-tr) 0
+ (147*K+ 5*L+tr) 0    (147*K+ 6*L-tr) 0
+ (147*K+ 6*L+tr) 0    (147*K+ 7*L-tr) 0
+ (147*K+ 7*L+tr) 0    (147*K+ 8*L-tr) 0
+ (147*K+ 8*L+tr) 0    (147*K+ 9*L-tr) 0
+ (147*K+ 9*L+tr) 0    (147*K+10*L-tr) 0
+ (147*K+10*L+tr) 0    (147*K+11*L-tr) 0
+ (147*K+11*L+tr) 0    (147*K+12*L-tr) 0
+ (147*K+12*L+tr) 0    (147*K+13*L-tr) 0
+ (147*K+13*L+tr) 0    (147*K+14*L-tr) 0
+ ]
vA6 (A6 0) vsource type=pwl wave=\[
+ ( 0*K   ) 0    ( 1*K-tr) 0
+ ( 1*K+tr) 0    ( 2*K-tr) 0
+ ( 2*K+tr) 0    ( 3*K-tr) 0
+ ( 3*K+tr) 0    ( 4*K-tr) 0
+ ( 4*K+tr) 0    ( 5*K-tr) 0
+ ( 5*K+tr) 0    ( 6*K-tr) 0
+ ( 6*K+tr) 0    ( 7*K-tr) 0
+ ( 7*K+tr) 0    ( 8*K-tr) 0
+ ( 8*K+tr) 0    ( 9*K-tr) 0
+ ( 9*K+tr) 0    (10*K-tr) 0
+ (10*K+tr) 0    (11*K-tr) 0
+ (11*K+tr) 0    (12*K-tr) 0
+ (12*K+tr) 0    (13*K-tr) 0
+ (13*K+tr) 0    (14*K-tr) 0
+ (14*K+tr) 0    (15*K-tr) 0
+ (15*K+tr) 0    (16*K-tr) 0
+ (16*K+tr) 0    (17*K-tr) 0
+ (17*K+tr) 0    (18*K-tr) 0
+ (18*K+tr) 0    (19*K-tr) 0
+ (19*K+tr) 0    (20*K-tr) 0
+ (20*K+tr) 0    (21*K-tr) 0
+ (21*K+tr) VDD  (22*K-tr) VDD
+ (22*K+tr) VDD  (23*K-tr) VDD
+ (23*K+tr) VDD  (24*K-tr) VDD
+ (24*K+tr) VDD  (25*K-tr) VDD
+ (25*K+tr) VDD  (26*K-tr) VDD
+ (26*K+tr) VDD  (27*K-tr) VDD
+ (27*K+tr) VDD  (28*K-tr) VDD
+ (28*K+tr) VDD  (29*K-tr) VDD
+ (29*K+tr) VDD  (30*K-tr) VDD
+ (30*K+tr) VDD  (31*K-tr) VDD
+ (31*K+tr) VDD  (32*K-tr) VDD
+ (32*K+tr) VDD  (33*K-tr) VDD
+ (33*K+tr) VDD  (34*K-tr) VDD
+ (34*K+tr) VDD  (35*K-tr) VDD
+ (35*K+tr) VDD  (36*K-tr) VDD
+ (36*K+tr) VDD  (37*K-tr) VDD
+ (37*K+tr) VDD  (38*K-tr) VDD
+ (38*K+tr) VDD  (39*K-tr) VDD
+ (39*K+tr) 0    (40*K-tr) 0
+ (40*K+tr) 0    (41*K-tr) 0
+ (41*K+tr) 0    (42*K-tr) 0
+ (42*K+tr) 0    (43*K-tr) 0
+ (43*K+tr) 0    (44*K-tr) 0
+ (44*K+tr) 0    (45*K-tr) 0
+ (45*K+tr) 0    (46*K-tr) 0
+ (46*K+tr) 0    (47*K-tr) 0
+ (47*K+tr) 0    (48*K-tr) 0
+ (48*K+tr) 0    (49*K-tr) 0
+ (49*K+tr) 0    (50*K-tr) 0
+ (50*K+tr) 0    (51*K-tr) 0
+ (51*K+tr) 0    (52*K-tr) 0
+ (52*K+tr) 0    (53*K-tr) 0
+ (53*K+tr) 0    (54*K-tr) 0
+ (54*K+tr) 0    (55*K-tr) 0
+ (55*K+tr) 0    (56*K-tr) 0
+ (56*K+tr) 0    (57*K-tr) 0
+ (57*K+tr) VDD  (58*K-tr) VDD
+ (58*K+tr) VDD  (59*K-tr) VDD
+ (59*K+tr) VDD  (60*K-tr) VDD
+ (60*K+tr) VDD  (61*K-tr) VDD
+ (61*K+tr) VDD  (62*K-tr) VDD
+ (62*K+tr) VDD  (63*K-tr) VDD
+ (63*K+tr) VDD  (64*K-tr) VDD
+ (64*K+tr) VDD  (65*K-tr) VDD
+ (65*K+tr) VDD  (66*K-tr) VDD
+ (66*K+tr) VDD  (67*K-tr) VDD
+ (67*K+tr) VDD  (68*K-tr) VDD
+ (68*K+tr) VDD  (69*K-tr) VDD
+ (69*K+tr) VDD  (70*K-tr) VDD
+ (70*K+tr) VDD  (71*K-tr) VDD
+ (71*K+tr) VDD  (72*K-tr) VDD
+ (72*K+tr) VDD  (73*K-tr) VDD
+ (73*K+tr) VDD  (74*K-tr) VDD
+ (74*K+tr) VDD  (75*K-tr) VDD
+ (75*K+tr) 0    (76*K-tr) 0
+ (76*K+tr) 0    (77*K-tr) 0
+ (77*K+tr) 0    (78*K-tr) 0
+ (78*K+tr) 0    (79*K-tr) 0
+ (79*K+tr) 0    (80*K-tr) 0
+ (80*K+tr) 0    (81*K-tr) 0
+ (81*K+tr) 0    (82*K-tr) 0
+ (82*K+tr) 0    (83*K-tr) 0
+ (83*K+tr) 0    (84*K-tr) 0
+ (84*K+tr) 0    (85*K-tr) 0
+ (85*K+tr) 0    (86*K-tr) 0
+ (86*K+tr) 0    (87*K-tr) 0
+ (87*K+tr) 0    (88*K-tr) 0
+ (88*K+tr) 0    (89*K-tr) 0
+ (89*K+tr) 0    (90*K-tr) 0
+ (90*K+tr) 0    (91*K-tr) 0
+ (91*K+tr) 0    (92*K-tr) 0
+ (92*K+tr) 0    (93*K-tr) 0
+ (93*K+tr) VDD  (94*K-tr) VDD
+ (94*K+tr) VDD  (95*K-tr) VDD
+ (95*K+tr) VDD  (96*K-tr) VDD
+ (96*K+tr) VDD  (97*K-tr) VDD
+ (97*K+tr) VDD  (98*K-tr) VDD
+ (98*K+tr) VDD  (99*K-tr) VDD
+ (99*K+tr) VDD  (100*K-tr) VDD
+ (100*K+tr) VDD  (101*K-tr) VDD
+ (101*K+tr) VDD  (102*K-tr) VDD
+ (102*K+tr) VDD  (103*K-tr) VDD
+ (103*K+tr) VDD  (104*K-tr) VDD
+ (104*K+tr) VDD  (105*K-tr) VDD
+ (105*K+tr) VDD  (106*K-tr) VDD
+ (106*K+tr) VDD  (107*K-tr) VDD
+ (107*K+tr) VDD  (108*K-tr) VDD
+ (108*K+tr) VDD  (109*K-tr) VDD
+ (109*K+tr) VDD  (110*K-tr) VDD
+ (110*K+tr) VDD  (111*K-tr) VDD
+ (111*K+tr) 0    (112*K-tr) 0
+ (112*K+tr) 0    (113*K-tr) 0
+ (113*K+tr) 0    (114*K-tr) 0
+ (114*K+tr) 0    (115*K-tr) 0
+ (115*K+tr) 0    (116*K-tr) 0
+ (116*K+tr) 0    (117*K-tr) 0
+ (117*K+tr) 0    (118*K-tr) 0
+ (118*K+tr) 0    (119*K-tr) 0
+ (119*K+tr) 0    (120*K-tr) 0
+ (120*K+tr) 0    (121*K-tr) 0
+ (121*K+tr) 0    (122*K-tr) 0
+ (122*K+tr) 0    (123*K-tr) 0
+ (123*K+tr) 0    (124*K-tr) 0
+ (124*K+tr) 0    (125*K-tr) 0
+ (125*K+tr) 0    (126*K-tr) 0
+ (126*K+tr) 0    (127*K-tr) 0
+ (127*K+tr) 0    (128*K-tr) 0
+ (128*K+tr) 0    (129*K-tr) 0
+ (129*K+tr) VDD  (130*K-tr) VDD
+ (130*K+tr) VDD  (131*K-tr) VDD
+ (131*K+tr) VDD  (132*K-tr) VDD
+ (132*K+tr) VDD  (133*K-tr) VDD
+ (133*K+tr) VDD  (134*K-tr) VDD
+ (134*K+tr) VDD  (135*K-tr) VDD
+ (135*K+tr) VDD  (136*K-tr) VDD
+ (136*K+tr) VDD  (137*K-tr) VDD
+ (137*K+tr) VDD  (138*K-tr) VDD
+ (138*K+tr) VDD  (139*K-tr) VDD
+ (139*K+tr) VDD  (140*K-tr) VDD
+ (140*K+tr) VDD  (141*K-tr) VDD
+ (141*K+tr) VDD  (142*K-tr) VDD
+ (142*K+tr) VDD  (143*K-tr) VDD
+ (143*K+tr) VDD  (144*K-tr) VDD
+ (144*K+tr) VDD  (145*K-tr) VDD
+ (145*K+tr) VDD  (146*K-tr) VDD
+ (146*K+tr) VDD  (147*K-tr) VDD
+ (147*K+ 0*L+tr) 0    (147*K+ 1*L-tr) 0
+ (147*K+ 1*L+tr) 0    (147*K+ 2*L-tr) 0
+ (147*K+ 2*L+tr) 0    (147*K+ 3*L-tr) 0
+ (147*K+ 3*L+tr) 0    (147*K+ 4*L-tr) 0
+ (147*K+ 4*L+tr) 0    (147*K+ 5*L-tr) 0
+ (147*K+ 5*L+tr) 0    (147*K+ 6*L-tr) 0
+ (147*K+ 6*L+tr) 0    (147*K+ 7*L-tr) 0
+ (147*K+ 7*L+tr) 0    (147*K+ 8*L-tr) 0
+ (147*K+ 8*L+tr) 0    (147*K+ 9*L-tr) 0
+ (147*K+ 9*L+tr) 0    (147*K+10*L-tr) 0
+ (147*K+10*L+tr) 0    (147*K+11*L-tr) 0
+ (147*K+11*L+tr) 0    (147*K+12*L-tr) 0
+ (147*K+12*L+tr) 0    (147*K+13*L-tr) 0
+ (147*K+13*L+tr) 0    (147*K+14*L-tr) 0
+ ]
vA7 (A7 0) vsource type=pwl wave=\[
+ ( 0*K   ) 0    ( 1*K-tr) 0
+ ( 1*K+tr) 0    ( 2*K-tr) 0
+ ( 2*K+tr) 0    ( 3*K-tr) 0
+ ( 3*K+tr) 0    ( 4*K-tr) 0
+ ( 4*K+tr) 0    ( 5*K-tr) 0
+ ( 5*K+tr) 0    ( 6*K-tr) 0
+ ( 6*K+tr) 0    ( 7*K-tr) 0
+ ( 7*K+tr) 0    ( 8*K-tr) 0
+ ( 8*K+tr) 0    ( 9*K-tr) 0
+ ( 9*K+tr) 0    (10*K-tr) 0
+ (10*K+tr) 0    (11*K-tr) 0
+ (11*K+tr) 0    (12*K-tr) 0
+ (12*K+tr) 0    (13*K-tr) 0
+ (13*K+tr) 0    (14*K-tr) 0
+ (14*K+tr) 0    (15*K-tr) 0
+ (15*K+tr) 0    (16*K-tr) 0
+ (16*K+tr) 0    (17*K-tr) 0
+ (17*K+tr) 0    (18*K-tr) 0
+ (18*K+tr) 0    (19*K-tr) 0
+ (19*K+tr) 0    (20*K-tr) 0
+ (20*K+tr) 0    (21*K-tr) 0
+ (21*K+tr) 0    (22*K-tr) 0
+ (22*K+tr) 0    (23*K-tr) 0
+ (23*K+tr) 0    (24*K-tr) 0
+ (24*K+tr) 0    (25*K-tr) 0
+ (25*K+tr) 0    (26*K-tr) 0
+ (26*K+tr) 0    (27*K-tr) 0
+ (27*K+tr) 0    (28*K-tr) 0
+ (28*K+tr) 0    (29*K-tr) 0
+ (29*K+tr) 0    (30*K-tr) 0
+ (30*K+tr) 0    (31*K-tr) 0
+ (31*K+tr) 0    (32*K-tr) 0
+ (32*K+tr) 0    (33*K-tr) 0
+ (33*K+tr) 0    (34*K-tr) 0
+ (34*K+tr) 0    (35*K-tr) 0
+ (35*K+tr) 0    (36*K-tr) 0
+ (36*K+tr) 0    (37*K-tr) 0
+ (37*K+tr) 0    (38*K-tr) 0
+ (38*K+tr) 0    (39*K-tr) 0
+ (39*K+tr) VDD  (40*K-tr) VDD
+ (40*K+tr) VDD  (41*K-tr) VDD
+ (41*K+tr) VDD  (42*K-tr) VDD
+ (42*K+tr) VDD  (43*K-tr) VDD
+ (43*K+tr) VDD  (44*K-tr) VDD
+ (44*K+tr) VDD  (45*K-tr) VDD
+ (45*K+tr) VDD  (46*K-tr) VDD
+ (46*K+tr) VDD  (47*K-tr) VDD
+ (47*K+tr) VDD  (48*K-tr) VDD
+ (48*K+tr) VDD  (49*K-tr) VDD
+ (49*K+tr) VDD  (50*K-tr) VDD
+ (50*K+tr) VDD  (51*K-tr) VDD
+ (51*K+tr) VDD  (52*K-tr) VDD
+ (52*K+tr) VDD  (53*K-tr) VDD
+ (53*K+tr) VDD  (54*K-tr) VDD
+ (54*K+tr) VDD  (55*K-tr) VDD
+ (55*K+tr) VDD  (56*K-tr) VDD
+ (56*K+tr) VDD  (57*K-tr) VDD
+ (57*K+tr) VDD  (58*K-tr) VDD
+ (58*K+tr) VDD  (59*K-tr) VDD
+ (59*K+tr) VDD  (60*K-tr) VDD
+ (60*K+tr) VDD  (61*K-tr) VDD
+ (61*K+tr) VDD  (62*K-tr) VDD
+ (62*K+tr) VDD  (63*K-tr) VDD
+ (63*K+tr) VDD  (64*K-tr) VDD
+ (64*K+tr) VDD  (65*K-tr) VDD
+ (65*K+tr) VDD  (66*K-tr) VDD
+ (66*K+tr) VDD  (67*K-tr) VDD
+ (67*K+tr) VDD  (68*K-tr) VDD
+ (68*K+tr) VDD  (69*K-tr) VDD
+ (69*K+tr) VDD  (70*K-tr) VDD
+ (70*K+tr) VDD  (71*K-tr) VDD
+ (71*K+tr) VDD  (72*K-tr) VDD
+ (72*K+tr) VDD  (73*K-tr) VDD
+ (73*K+tr) VDD  (74*K-tr) VDD
+ (74*K+tr) VDD  (75*K-tr) VDD
+ (75*K+tr) 0    (76*K-tr) 0
+ (76*K+tr) 0    (77*K-tr) 0
+ (77*K+tr) 0    (78*K-tr) 0
+ (78*K+tr) 0    (79*K-tr) 0
+ (79*K+tr) 0    (80*K-tr) 0
+ (80*K+tr) 0    (81*K-tr) 0
+ (81*K+tr) 0    (82*K-tr) 0
+ (82*K+tr) 0    (83*K-tr) 0
+ (83*K+tr) 0    (84*K-tr) 0
+ (84*K+tr) 0    (85*K-tr) 0
+ (85*K+tr) 0    (86*K-tr) 0
+ (86*K+tr) 0    (87*K-tr) 0
+ (87*K+tr) 0    (88*K-tr) 0
+ (88*K+tr) 0    (89*K-tr) 0
+ (89*K+tr) 0    (90*K-tr) 0
+ (90*K+tr) 0    (91*K-tr) 0
+ (91*K+tr) 0    (92*K-tr) 0
+ (92*K+tr) 0    (93*K-tr) 0
+ (93*K+tr) 0    (94*K-tr) 0
+ (94*K+tr) 0    (95*K-tr) 0
+ (95*K+tr) 0    (96*K-tr) 0
+ (96*K+tr) 0    (97*K-tr) 0
+ (97*K+tr) 0    (98*K-tr) 0
+ (98*K+tr) 0    (99*K-tr) 0
+ (99*K+tr) 0    (100*K-tr) 0
+ (100*K+tr) 0    (101*K-tr) 0
+ (101*K+tr) 0    (102*K-tr) 0
+ (102*K+tr) 0    (103*K-tr) 0
+ (103*K+tr) 0    (104*K-tr) 0
+ (104*K+tr) 0    (105*K-tr) 0
+ (105*K+tr) 0    (106*K-tr) 0
+ (106*K+tr) 0    (107*K-tr) 0
+ (107*K+tr) 0    (108*K-tr) 0
+ (108*K+tr) 0    (109*K-tr) 0
+ (109*K+tr) 0    (110*K-tr) 0
+ (110*K+tr) 0    (111*K-tr) 0
+ (111*K+tr) VDD  (112*K-tr) VDD
+ (112*K+tr) VDD  (113*K-tr) VDD
+ (113*K+tr) VDD  (114*K-tr) VDD
+ (114*K+tr) VDD  (115*K-tr) VDD
+ (115*K+tr) VDD  (116*K-tr) VDD
+ (116*K+tr) VDD  (117*K-tr) VDD
+ (117*K+tr) VDD  (118*K-tr) VDD
+ (118*K+tr) VDD  (119*K-tr) VDD
+ (119*K+tr) VDD  (120*K-tr) VDD
+ (120*K+tr) VDD  (121*K-tr) VDD
+ (121*K+tr) VDD  (122*K-tr) VDD
+ (122*K+tr) VDD  (123*K-tr) VDD
+ (123*K+tr) VDD  (124*K-tr) VDD
+ (124*K+tr) VDD  (125*K-tr) VDD
+ (125*K+tr) VDD  (126*K-tr) VDD
+ (126*K+tr) VDD  (127*K-tr) VDD
+ (127*K+tr) VDD  (128*K-tr) VDD
+ (128*K+tr) VDD  (129*K-tr) VDD
+ (129*K+tr) VDD  (130*K-tr) VDD
+ (130*K+tr) VDD  (131*K-tr) VDD
+ (131*K+tr) VDD  (132*K-tr) VDD
+ (132*K+tr) VDD  (133*K-tr) VDD
+ (133*K+tr) VDD  (134*K-tr) VDD
+ (134*K+tr) VDD  (135*K-tr) VDD
+ (135*K+tr) VDD  (136*K-tr) VDD
+ (136*K+tr) VDD  (137*K-tr) VDD
+ (137*K+tr) VDD  (138*K-tr) VDD
+ (138*K+tr) VDD  (139*K-tr) VDD
+ (139*K+tr) VDD  (140*K-tr) VDD
+ (140*K+tr) VDD  (141*K-tr) VDD
+ (141*K+tr) VDD  (142*K-tr) VDD
+ (142*K+tr) VDD  (143*K-tr) VDD
+ (143*K+tr) VDD  (144*K-tr) VDD
+ (144*K+tr) VDD  (145*K-tr) VDD
+ (145*K+tr) VDD  (146*K-tr) VDD
+ (146*K+tr) VDD  (147*K-tr) VDD
+ (147*K+ 0*L+tr) 0    (147*K+ 1*L-tr) 0
+ (147*K+ 1*L+tr) 0    (147*K+ 2*L-tr) 0
+ (147*K+ 2*L+tr) 0    (147*K+ 3*L-tr) 0
+ (147*K+ 3*L+tr) 0    (147*K+ 4*L-tr) 0
+ (147*K+ 4*L+tr) 0    (147*K+ 5*L-tr) 0
+ (147*K+ 5*L+tr) 0    (147*K+ 6*L-tr) 0
+ (147*K+ 6*L+tr) 0    (147*K+ 7*L-tr) 0
+ (147*K+ 7*L+tr) 0    (147*K+ 8*L-tr) 0
+ (147*K+ 8*L+tr) 0    (147*K+ 9*L-tr) 0
+ (147*K+ 9*L+tr) 0    (147*K+10*L-tr) 0
+ (147*K+10*L+tr) 0    (147*K+11*L-tr) 0
+ (147*K+11*L+tr) 0    (147*K+12*L-tr) 0
+ (147*K+12*L+tr) 0    (147*K+13*L-tr) 0
+ (147*K+13*L+tr) 0    (147*K+14*L-tr) 0
+ ]
vA8 (A8 0) vsource type=pwl wave=\[
+ ( 0*K   ) 0    ( 1*K-tr) 0
+ ( 1*K+tr) 0    ( 2*K-tr) 0
+ ( 2*K+tr) 0    ( 3*K-tr) 0
+ ( 3*K+tr) 0    ( 4*K-tr) 0
+ ( 4*K+tr) 0    ( 5*K-tr) 0
+ ( 5*K+tr) 0    ( 6*K-tr) 0
+ ( 6*K+tr) 0    ( 7*K-tr) 0
+ ( 7*K+tr) 0    ( 8*K-tr) 0
+ ( 8*K+tr) 0    ( 9*K-tr) 0
+ ( 9*K+tr) 0    (10*K-tr) 0
+ (10*K+tr) 0    (11*K-tr) 0
+ (11*K+tr) 0    (12*K-tr) 0
+ (12*K+tr) 0    (13*K-tr) 0
+ (13*K+tr) 0    (14*K-tr) 0
+ (14*K+tr) 0    (15*K-tr) 0
+ (15*K+tr) 0    (16*K-tr) 0
+ (16*K+tr) 0    (17*K-tr) 0
+ (17*K+tr) 0    (18*K-tr) 0
+ (18*K+tr) 0    (19*K-tr) 0
+ (19*K+tr) 0    (20*K-tr) 0
+ (20*K+tr) 0    (21*K-tr) 0
+ (21*K+tr) 0    (22*K-tr) 0
+ (22*K+tr) 0    (23*K-tr) 0
+ (23*K+tr) 0    (24*K-tr) 0
+ (24*K+tr) 0    (25*K-tr) 0
+ (25*K+tr) 0    (26*K-tr) 0
+ (26*K+tr) 0    (27*K-tr) 0
+ (27*K+tr) 0    (28*K-tr) 0
+ (28*K+tr) 0    (29*K-tr) 0
+ (29*K+tr) 0    (30*K-tr) 0
+ (30*K+tr) 0    (31*K-tr) 0
+ (31*K+tr) 0    (32*K-tr) 0
+ (32*K+tr) 0    (33*K-tr) 0
+ (33*K+tr) 0    (34*K-tr) 0
+ (34*K+tr) 0    (35*K-tr) 0
+ (35*K+tr) 0    (36*K-tr) 0
+ (36*K+tr) 0    (37*K-tr) 0
+ (37*K+tr) 0    (38*K-tr) 0
+ (38*K+tr) 0    (39*K-tr) 0
+ (39*K+tr) 0    (40*K-tr) 0
+ (40*K+tr) 0    (41*K-tr) 0
+ (41*K+tr) 0    (42*K-tr) 0
+ (42*K+tr) 0    (43*K-tr) 0
+ (43*K+tr) 0    (44*K-tr) 0
+ (44*K+tr) 0    (45*K-tr) 0
+ (45*K+tr) 0    (46*K-tr) 0
+ (46*K+tr) 0    (47*K-tr) 0
+ (47*K+tr) 0    (48*K-tr) 0
+ (48*K+tr) 0    (49*K-tr) 0
+ (49*K+tr) 0    (50*K-tr) 0
+ (50*K+tr) 0    (51*K-tr) 0
+ (51*K+tr) 0    (52*K-tr) 0
+ (52*K+tr) 0    (53*K-tr) 0
+ (53*K+tr) 0    (54*K-tr) 0
+ (54*K+tr) 0    (55*K-tr) 0
+ (55*K+tr) 0    (56*K-tr) 0
+ (56*K+tr) 0    (57*K-tr) 0
+ (57*K+tr) 0    (58*K-tr) 0
+ (58*K+tr) 0    (59*K-tr) 0
+ (59*K+tr) 0    (60*K-tr) 0
+ (60*K+tr) 0    (61*K-tr) 0
+ (61*K+tr) 0    (62*K-tr) 0
+ (62*K+tr) 0    (63*K-tr) 0
+ (63*K+tr) 0    (64*K-tr) 0
+ (64*K+tr) 0    (65*K-tr) 0
+ (65*K+tr) 0    (66*K-tr) 0
+ (66*K+tr) 0    (67*K-tr) 0
+ (67*K+tr) 0    (68*K-tr) 0
+ (68*K+tr) 0    (69*K-tr) 0
+ (69*K+tr) 0    (70*K-tr) 0
+ (70*K+tr) 0    (71*K-tr) 0
+ (71*K+tr) 0    (72*K-tr) 0
+ (72*K+tr) 0    (73*K-tr) 0
+ (73*K+tr) 0    (74*K-tr) 0
+ (74*K+tr) 0    (75*K-tr) 0
+ (75*K+tr) VDD  (76*K-tr) VDD
+ (76*K+tr) VDD  (77*K-tr) VDD
+ (77*K+tr) VDD  (78*K-tr) VDD
+ (78*K+tr) VDD  (79*K-tr) VDD
+ (79*K+tr) VDD  (80*K-tr) VDD
+ (80*K+tr) VDD  (81*K-tr) VDD
+ (81*K+tr) VDD  (82*K-tr) VDD
+ (82*K+tr) VDD  (83*K-tr) VDD
+ (83*K+tr) VDD  (84*K-tr) VDD
+ (84*K+tr) VDD  (85*K-tr) VDD
+ (85*K+tr) VDD  (86*K-tr) VDD
+ (86*K+tr) VDD  (87*K-tr) VDD
+ (87*K+tr) VDD  (88*K-tr) VDD
+ (88*K+tr) VDD  (89*K-tr) VDD
+ (89*K+tr) VDD  (90*K-tr) VDD
+ (90*K+tr) VDD  (91*K-tr) VDD
+ (91*K+tr) VDD  (92*K-tr) VDD
+ (92*K+tr) VDD  (93*K-tr) VDD
+ (93*K+tr) VDD  (94*K-tr) VDD
+ (94*K+tr) VDD  (95*K-tr) VDD
+ (95*K+tr) VDD  (96*K-tr) VDD
+ (96*K+tr) VDD  (97*K-tr) VDD
+ (97*K+tr) VDD  (98*K-tr) VDD
+ (98*K+tr) VDD  (99*K-tr) VDD
+ (99*K+tr) VDD  (100*K-tr) VDD
+ (100*K+tr) VDD  (101*K-tr) VDD
+ (101*K+tr) VDD  (102*K-tr) VDD
+ (102*K+tr) VDD  (103*K-tr) VDD
+ (103*K+tr) VDD  (104*K-tr) VDD
+ (104*K+tr) VDD  (105*K-tr) VDD
+ (105*K+tr) VDD  (106*K-tr) VDD
+ (106*K+tr) VDD  (107*K-tr) VDD
+ (107*K+tr) VDD  (108*K-tr) VDD
+ (108*K+tr) VDD  (109*K-tr) VDD
+ (109*K+tr) VDD  (110*K-tr) VDD
+ (110*K+tr) VDD  (111*K-tr) VDD
+ (111*K+tr) VDD  (112*K-tr) VDD
+ (112*K+tr) VDD  (113*K-tr) VDD
+ (113*K+tr) VDD  (114*K-tr) VDD
+ (114*K+tr) VDD  (115*K-tr) VDD
+ (115*K+tr) VDD  (116*K-tr) VDD
+ (116*K+tr) VDD  (117*K-tr) VDD
+ (117*K+tr) VDD  (118*K-tr) VDD
+ (118*K+tr) VDD  (119*K-tr) VDD
+ (119*K+tr) VDD  (120*K-tr) VDD
+ (120*K+tr) VDD  (121*K-tr) VDD
+ (121*K+tr) VDD  (122*K-tr) VDD
+ (122*K+tr) VDD  (123*K-tr) VDD
+ (123*K+tr) VDD  (124*K-tr) VDD
+ (124*K+tr) VDD  (125*K-tr) VDD
+ (125*K+tr) VDD  (126*K-tr) VDD
+ (126*K+tr) VDD  (127*K-tr) VDD
+ (127*K+tr) VDD  (128*K-tr) VDD
+ (128*K+tr) VDD  (129*K-tr) VDD
+ (129*K+tr) VDD  (130*K-tr) VDD
+ (130*K+tr) VDD  (131*K-tr) VDD
+ (131*K+tr) VDD  (132*K-tr) VDD
+ (132*K+tr) VDD  (133*K-tr) VDD
+ (133*K+tr) VDD  (134*K-tr) VDD
+ (134*K+tr) VDD  (135*K-tr) VDD
+ (135*K+tr) VDD  (136*K-tr) VDD
+ (136*K+tr) VDD  (137*K-tr) VDD
+ (137*K+tr) VDD  (138*K-tr) VDD
+ (138*K+tr) VDD  (139*K-tr) VDD
+ (139*K+tr) VDD  (140*K-tr) VDD
+ (140*K+tr) VDD  (141*K-tr) VDD
+ (141*K+tr) VDD  (142*K-tr) VDD
+ (142*K+tr) VDD  (143*K-tr) VDD
+ (143*K+tr) VDD  (144*K-tr) VDD
+ (144*K+tr) VDD  (145*K-tr) VDD
+ (145*K+tr) VDD  (146*K-tr) VDD
+ (146*K+tr) VDD  (147*K-tr) VDD
+ (147*K+ 0*L+tr) 0    (147*K+ 1*L-tr) 0
+ (147*K+ 1*L+tr) 0    (147*K+ 2*L-tr) 0
+ (147*K+ 2*L+tr) 0    (147*K+ 3*L-tr) 0
+ (147*K+ 3*L+tr) 0    (147*K+ 4*L-tr) 0
+ (147*K+ 4*L+tr) 0    (147*K+ 5*L-tr) 0
+ (147*K+ 5*L+tr) 0    (147*K+ 6*L-tr) 0
+ (147*K+ 6*L+tr) 0    (147*K+ 7*L-tr) 0
+ (147*K+ 7*L+tr) 0    (147*K+ 8*L-tr) 0
+ (147*K+ 8*L+tr) 0    (147*K+ 9*L-tr) 0
+ (147*K+ 9*L+tr) 0    (147*K+10*L-tr) 0
+ (147*K+10*L+tr) 0    (147*K+11*L-tr) 0
+ (147*K+11*L+tr) 0    (147*K+12*L-tr) 0
+ (147*K+12*L+tr) 0    (147*K+13*L-tr) 0
+ (147*K+13*L+tr) 0    (147*K+14*L-tr) 0
+ ]
vA9 (A9 0) vsource type=pwl wave=\[
+ ( 0*K   ) 0    ( 1*K-tr) 0
+ ( 1*K+tr) 0    ( 2*K-tr) 0
+ ( 2*K+tr) 0    ( 3*K-tr) 0
+ ( 3*K+tr) 0    ( 4*K-tr) 0
+ ( 4*K+tr) 0    ( 5*K-tr) 0
+ ( 5*K+tr) 0    ( 6*K-tr) 0
+ ( 6*K+tr) 0    ( 7*K-tr) 0
+ ( 7*K+tr) 0    ( 8*K-tr) 0
+ ( 8*K+tr) 0    ( 9*K-tr) 0
+ ( 9*K+tr) 0    (10*K-tr) 0
+ (10*K+tr) 0    (11*K-tr) 0
+ (11*K+tr) 0    (12*K-tr) 0
+ (12*K+tr) 0    (13*K-tr) 0
+ (13*K+tr) 0    (14*K-tr) 0
+ (14*K+tr) 0    (15*K-tr) 0
+ (15*K+tr) 0    (16*K-tr) 0
+ (16*K+tr) 0    (17*K-tr) 0
+ (17*K+tr) 0    (18*K-tr) 0
+ (18*K+tr) 0    (19*K-tr) 0
+ (19*K+tr) 0    (20*K-tr) 0
+ (20*K+tr) 0    (21*K-tr) 0
+ (21*K+tr) 0    (22*K-tr) 0
+ (22*K+tr) 0    (23*K-tr) 0
+ (23*K+tr) 0    (24*K-tr) 0
+ (24*K+tr) 0    (25*K-tr) 0
+ (25*K+tr) 0    (26*K-tr) 0
+ (26*K+tr) 0    (27*K-tr) 0
+ (27*K+tr) 0    (28*K-tr) 0
+ (28*K+tr) 0    (29*K-tr) 0
+ (29*K+tr) 0    (30*K-tr) 0
+ (30*K+tr) 0    (31*K-tr) 0
+ (31*K+tr) 0    (32*K-tr) 0
+ (32*K+tr) 0    (33*K-tr) 0
+ (33*K+tr) 0    (34*K-tr) 0
+ (34*K+tr) 0    (35*K-tr) 0
+ (35*K+tr) 0    (36*K-tr) 0
+ (36*K+tr) 0    (37*K-tr) 0
+ (37*K+tr) 0    (38*K-tr) 0
+ (38*K+tr) 0    (39*K-tr) 0
+ (39*K+tr) 0    (40*K-tr) 0
+ (40*K+tr) 0    (41*K-tr) 0
+ (41*K+tr) 0    (42*K-tr) 0
+ (42*K+tr) 0    (43*K-tr) 0
+ (43*K+tr) 0    (44*K-tr) 0
+ (44*K+tr) 0    (45*K-tr) 0
+ (45*K+tr) 0    (46*K-tr) 0
+ (46*K+tr) 0    (47*K-tr) 0
+ (47*K+tr) 0    (48*K-tr) 0
+ (48*K+tr) 0    (49*K-tr) 0
+ (49*K+tr) 0    (50*K-tr) 0
+ (50*K+tr) 0    (51*K-tr) 0
+ (51*K+tr) 0    (52*K-tr) 0
+ (52*K+tr) 0    (53*K-tr) 0
+ (53*K+tr) 0    (54*K-tr) 0
+ (54*K+tr) 0    (55*K-tr) 0
+ (55*K+tr) 0    (56*K-tr) 0
+ (56*K+tr) 0    (57*K-tr) 0
+ (57*K+tr) 0    (58*K-tr) 0
+ (58*K+tr) 0    (59*K-tr) 0
+ (59*K+tr) 0    (60*K-tr) 0
+ (60*K+tr) 0    (61*K-tr) 0
+ (61*K+tr) 0    (62*K-tr) 0
+ (62*K+tr) 0    (63*K-tr) 0
+ (63*K+tr) 0    (64*K-tr) 0
+ (64*K+tr) 0    (65*K-tr) 0
+ (65*K+tr) 0    (66*K-tr) 0
+ (66*K+tr) 0    (67*K-tr) 0
+ (67*K+tr) 0    (68*K-tr) 0
+ (68*K+tr) 0    (69*K-tr) 0
+ (69*K+tr) 0    (70*K-tr) 0
+ (70*K+tr) 0    (71*K-tr) 0
+ (71*K+tr) 0    (72*K-tr) 0
+ (72*K+tr) 0    (73*K-tr) 0
+ (73*K+tr) 0    (74*K-tr) 0
+ (74*K+tr) 0    (75*K-tr) 0
+ (75*K+tr) 0    (76*K-tr) 0
+ (76*K+tr) 0    (77*K-tr) 0
+ (77*K+tr) 0    (78*K-tr) 0
+ (78*K+tr) 0    (79*K-tr) 0
+ (79*K+tr) 0    (80*K-tr) 0
+ (80*K+tr) 0    (81*K-tr) 0
+ (81*K+tr) 0    (82*K-tr) 0
+ (82*K+tr) 0    (83*K-tr) 0
+ (83*K+tr) 0    (84*K-tr) 0
+ (84*K+tr) 0    (85*K-tr) 0
+ (85*K+tr) 0    (86*K-tr) 0
+ (86*K+tr) 0    (87*K-tr) 0
+ (87*K+tr) 0    (88*K-tr) 0
+ (88*K+tr) 0    (89*K-tr) 0
+ (89*K+tr) 0    (90*K-tr) 0
+ (90*K+tr) 0    (91*K-tr) 0
+ (91*K+tr) 0    (92*K-tr) 0
+ (92*K+tr) 0    (93*K-tr) 0
+ (93*K+tr) 0    (94*K-tr) 0
+ (94*K+tr) 0    (95*K-tr) 0
+ (95*K+tr) 0    (96*K-tr) 0
+ (96*K+tr) 0    (97*K-tr) 0
+ (97*K+tr) 0    (98*K-tr) 0
+ (98*K+tr) 0    (99*K-tr) 0
+ (99*K+tr) 0    (100*K-tr) 0
+ (100*K+tr) 0    (101*K-tr) 0
+ (101*K+tr) 0    (102*K-tr) 0
+ (102*K+tr) 0    (103*K-tr) 0
+ (103*K+tr) 0    (104*K-tr) 0
+ (104*K+tr) 0    (105*K-tr) 0
+ (105*K+tr) 0    (106*K-tr) 0
+ (106*K+tr) 0    (107*K-tr) 0
+ (107*K+tr) 0    (108*K-tr) 0
+ (108*K+tr) 0    (109*K-tr) 0
+ (109*K+tr) 0    (110*K-tr) 0
+ (110*K+tr) 0    (111*K-tr) 0
+ (111*K+tr) 0    (112*K-tr) 0
+ (112*K+tr) 0    (113*K-tr) 0
+ (113*K+tr) 0    (114*K-tr) 0
+ (114*K+tr) 0    (115*K-tr) 0
+ (115*K+tr) 0    (116*K-tr) 0
+ (116*K+tr) 0    (117*K-tr) 0
+ (117*K+tr) 0    (118*K-tr) 0
+ (118*K+tr) 0    (119*K-tr) 0
+ (119*K+tr) 0    (120*K-tr) 0
+ (120*K+tr) 0    (121*K-tr) 0
+ (121*K+tr) 0    (122*K-tr) 0
+ (122*K+tr) 0    (123*K-tr) 0
+ (123*K+tr) 0    (124*K-tr) 0
+ (124*K+tr) 0    (125*K-tr) 0
+ (125*K+tr) 0    (126*K-tr) 0
+ (126*K+tr) 0    (127*K-tr) 0
+ (127*K+tr) 0    (128*K-tr) 0
+ (128*K+tr) 0    (129*K-tr) 0
+ (129*K+tr) 0    (130*K-tr) 0
+ (130*K+tr) 0    (131*K-tr) 0
+ (131*K+tr) 0    (132*K-tr) 0
+ (132*K+tr) 0    (133*K-tr) 0
+ (133*K+tr) 0    (134*K-tr) 0
+ (134*K+tr) 0    (135*K-tr) 0
+ (135*K+tr) 0    (136*K-tr) 0
+ (136*K+tr) 0    (137*K-tr) 0
+ (137*K+tr) 0    (138*K-tr) 0
+ (138*K+tr) 0    (139*K-tr) 0
+ (139*K+tr) 0    (140*K-tr) 0
+ (140*K+tr) 0    (141*K-tr) 0
+ (141*K+tr) 0    (142*K-tr) 0
+ (142*K+tr) 0    (143*K-tr) 0
+ (143*K+tr) 0    (144*K-tr) 0
+ (144*K+tr) 0    (145*K-tr) 0
+ (145*K+tr) 0    (146*K-tr) 0
+ (146*K+tr) 0    (147*K-tr) 0
+ (147*K+ 0*L+tr) 0    (147*K+ 1*L-tr) 0
+ (147*K+ 1*L+tr) 0    (147*K+ 2*L-tr) 0
+ (147*K+ 2*L+tr) 0    (147*K+ 3*L-tr) 0
+ (147*K+ 3*L+tr) 0    (147*K+ 4*L-tr) 0
+ (147*K+ 4*L+tr) 0    (147*K+ 5*L-tr) 0
+ (147*K+ 5*L+tr) 0    (147*K+ 6*L-tr) 0
+ (147*K+ 6*L+tr) 0    (147*K+ 7*L-tr) 0
+ (147*K+ 7*L+tr) 0    (147*K+ 8*L-tr) 0
+ (147*K+ 8*L+tr) 0    (147*K+ 9*L-tr) 0
+ (147*K+ 9*L+tr) 0    (147*K+10*L-tr) 0
+ (147*K+10*L+tr) 0    (147*K+11*L-tr) 0
+ (147*K+11*L+tr) 0    (147*K+12*L-tr) 0
+ (147*K+12*L+tr) 0    (147*K+13*L-tr) 0
+ (147*K+13*L+tr) 0    (147*K+14*L-tr) 0
+ ]
vA10 (A10 0) vsource type=pwl wave=\[
+ ( 0*K   ) 0    ( 1*K-tr) 0
+ ( 1*K+tr) 0    ( 2*K-tr) 0
+ ( 2*K+tr) 0    ( 3*K-tr) 0
+ ( 3*K+tr) 0    ( 4*K-tr) 0
+ ( 4*K+tr) 0    ( 5*K-tr) 0
+ ( 5*K+tr) 0    ( 6*K-tr) 0
+ ( 6*K+tr) 0    ( 7*K-tr) 0
+ ( 7*K+tr) 0    ( 8*K-tr) 0
+ ( 8*K+tr) 0    ( 9*K-tr) 0
+ ( 9*K+tr) 0    (10*K-tr) 0
+ (10*K+tr) 0    (11*K-tr) 0
+ (11*K+tr) 0    (12*K-tr) 0
+ (12*K+tr) 0    (13*K-tr) 0
+ (13*K+tr) 0    (14*K-tr) 0
+ (14*K+tr) 0    (15*K-tr) 0
+ (15*K+tr) 0    (16*K-tr) 0
+ (16*K+tr) 0    (17*K-tr) 0
+ (17*K+tr) 0    (18*K-tr) 0
+ (18*K+tr) 0    (19*K-tr) 0
+ (19*K+tr) 0    (20*K-tr) 0
+ (20*K+tr) 0    (21*K-tr) 0
+ (21*K+tr) 0    (22*K-tr) 0
+ (22*K+tr) 0    (23*K-tr) 0
+ (23*K+tr) 0    (24*K-tr) 0
+ (24*K+tr) 0    (25*K-tr) 0
+ (25*K+tr) 0    (26*K-tr) 0
+ (26*K+tr) 0    (27*K-tr) 0
+ (27*K+tr) 0    (28*K-tr) 0
+ (28*K+tr) 0    (29*K-tr) 0
+ (29*K+tr) 0    (30*K-tr) 0
+ (30*K+tr) 0    (31*K-tr) 0
+ (31*K+tr) 0    (32*K-tr) 0
+ (32*K+tr) 0    (33*K-tr) 0
+ (33*K+tr) 0    (34*K-tr) 0
+ (34*K+tr) 0    (35*K-tr) 0
+ (35*K+tr) 0    (36*K-tr) 0
+ (36*K+tr) 0    (37*K-tr) 0
+ (37*K+tr) 0    (38*K-tr) 0
+ (38*K+tr) 0    (39*K-tr) 0
+ (39*K+tr) 0    (40*K-tr) 0
+ (40*K+tr) 0    (41*K-tr) 0
+ (41*K+tr) 0    (42*K-tr) 0
+ (42*K+tr) 0    (43*K-tr) 0
+ (43*K+tr) 0    (44*K-tr) 0
+ (44*K+tr) 0    (45*K-tr) 0
+ (45*K+tr) 0    (46*K-tr) 0
+ (46*K+tr) 0    (47*K-tr) 0
+ (47*K+tr) 0    (48*K-tr) 0
+ (48*K+tr) 0    (49*K-tr) 0
+ (49*K+tr) 0    (50*K-tr) 0
+ (50*K+tr) 0    (51*K-tr) 0
+ (51*K+tr) 0    (52*K-tr) 0
+ (52*K+tr) 0    (53*K-tr) 0
+ (53*K+tr) 0    (54*K-tr) 0
+ (54*K+tr) 0    (55*K-tr) 0
+ (55*K+tr) 0    (56*K-tr) 0
+ (56*K+tr) 0    (57*K-tr) 0
+ (57*K+tr) 0    (58*K-tr) 0
+ (58*K+tr) 0    (59*K-tr) 0
+ (59*K+tr) 0    (60*K-tr) 0
+ (60*K+tr) 0    (61*K-tr) 0
+ (61*K+tr) 0    (62*K-tr) 0
+ (62*K+tr) 0    (63*K-tr) 0
+ (63*K+tr) 0    (64*K-tr) 0
+ (64*K+tr) 0    (65*K-tr) 0
+ (65*K+tr) 0    (66*K-tr) 0
+ (66*K+tr) 0    (67*K-tr) 0
+ (67*K+tr) 0    (68*K-tr) 0
+ (68*K+tr) 0    (69*K-tr) 0
+ (69*K+tr) 0    (70*K-tr) 0
+ (70*K+tr) 0    (71*K-tr) 0
+ (71*K+tr) 0    (72*K-tr) 0
+ (72*K+tr) 0    (73*K-tr) 0
+ (73*K+tr) 0    (74*K-tr) 0
+ (74*K+tr) 0    (75*K-tr) 0
+ (75*K+tr) 0    (76*K-tr) 0
+ (76*K+tr) 0    (77*K-tr) 0
+ (77*K+tr) 0    (78*K-tr) 0
+ (78*K+tr) 0    (79*K-tr) 0
+ (79*K+tr) 0    (80*K-tr) 0
+ (80*K+tr) 0    (81*K-tr) 0
+ (81*K+tr) 0    (82*K-tr) 0
+ (82*K+tr) 0    (83*K-tr) 0
+ (83*K+tr) 0    (84*K-tr) 0
+ (84*K+tr) 0    (85*K-tr) 0
+ (85*K+tr) 0    (86*K-tr) 0
+ (86*K+tr) 0    (87*K-tr) 0
+ (87*K+tr) 0    (88*K-tr) 0
+ (88*K+tr) 0    (89*K-tr) 0
+ (89*K+tr) 0    (90*K-tr) 0
+ (90*K+tr) 0    (91*K-tr) 0
+ (91*K+tr) 0    (92*K-tr) 0
+ (92*K+tr) 0    (93*K-tr) 0
+ (93*K+tr) 0    (94*K-tr) 0
+ (94*K+tr) 0    (95*K-tr) 0
+ (95*K+tr) 0    (96*K-tr) 0
+ (96*K+tr) 0    (97*K-tr) 0
+ (97*K+tr) 0    (98*K-tr) 0
+ (98*K+tr) 0    (99*K-tr) 0
+ (99*K+tr) 0    (100*K-tr) 0
+ (100*K+tr) 0    (101*K-tr) 0
+ (101*K+tr) 0    (102*K-tr) 0
+ (102*K+tr) 0    (103*K-tr) 0
+ (103*K+tr) 0    (104*K-tr) 0
+ (104*K+tr) 0    (105*K-tr) 0
+ (105*K+tr) 0    (106*K-tr) 0
+ (106*K+tr) 0    (107*K-tr) 0
+ (107*K+tr) 0    (108*K-tr) 0
+ (108*K+tr) 0    (109*K-tr) 0
+ (109*K+tr) 0    (110*K-tr) 0
+ (110*K+tr) 0    (111*K-tr) 0
+ (111*K+tr) 0    (112*K-tr) 0
+ (112*K+tr) 0    (113*K-tr) 0
+ (113*K+tr) 0    (114*K-tr) 0
+ (114*K+tr) 0    (115*K-tr) 0
+ (115*K+tr) 0    (116*K-tr) 0
+ (116*K+tr) 0    (117*K-tr) 0
+ (117*K+tr) 0    (118*K-tr) 0
+ (118*K+tr) 0    (119*K-tr) 0
+ (119*K+tr) 0    (120*K-tr) 0
+ (120*K+tr) 0    (121*K-tr) 0
+ (121*K+tr) 0    (122*K-tr) 0
+ (122*K+tr) 0    (123*K-tr) 0
+ (123*K+tr) 0    (124*K-tr) 0
+ (124*K+tr) 0    (125*K-tr) 0
+ (125*K+tr) 0    (126*K-tr) 0
+ (126*K+tr) 0    (127*K-tr) 0
+ (127*K+tr) 0    (128*K-tr) 0
+ (128*K+tr) 0    (129*K-tr) 0
+ (129*K+tr) 0    (130*K-tr) 0
+ (130*K+tr) 0    (131*K-tr) 0
+ (131*K+tr) 0    (132*K-tr) 0
+ (132*K+tr) 0    (133*K-tr) 0
+ (133*K+tr) 0    (134*K-tr) 0
+ (134*K+tr) 0    (135*K-tr) 0
+ (135*K+tr) 0    (136*K-tr) 0
+ (136*K+tr) 0    (137*K-tr) 0
+ (137*K+tr) 0    (138*K-tr) 0
+ (138*K+tr) 0    (139*K-tr) 0
+ (139*K+tr) 0    (140*K-tr) 0
+ (140*K+tr) 0    (141*K-tr) 0
+ (141*K+tr) 0    (142*K-tr) 0
+ (142*K+tr) 0    (143*K-tr) 0
+ (143*K+tr) 0    (144*K-tr) 0
+ (144*K+tr) 0    (145*K-tr) 0
+ (145*K+tr) 0    (146*K-tr) 0
+ (146*K+tr) 0    (147*K-tr) 0
+ (147*K+ 0*L+tr) 0    (147*K+ 1*L-tr) 0
+ (147*K+ 1*L+tr) 0    (147*K+ 2*L-tr) 0
+ (147*K+ 2*L+tr) 0    (147*K+ 3*L-tr) 0
+ (147*K+ 3*L+tr) 0    (147*K+ 4*L-tr) 0
+ (147*K+ 4*L+tr) 0    (147*K+ 5*L-tr) 0
+ (147*K+ 5*L+tr) 0    (147*K+ 6*L-tr) 0
+ (147*K+ 6*L+tr) 0    (147*K+ 7*L-tr) 0
+ (147*K+ 7*L+tr) 0    (147*K+ 8*L-tr) 0
+ (147*K+ 8*L+tr) 0    (147*K+ 9*L-tr) 0
+ (147*K+ 9*L+tr) 0    (147*K+10*L-tr) 0
+ (147*K+10*L+tr) 0    (147*K+11*L-tr) 0
+ (147*K+11*L+tr) 0    (147*K+12*L-tr) 0
+ (147*K+12*L+tr) 0    (147*K+13*L-tr) 0
+ (147*K+13*L+tr) 0    (147*K+14*L-tr) 0
+ ]
vA11 (A11 0) vsource type=pwl wave=\[
+ ( 0*K   ) 0    ( 1*K-tr) 0
+ ( 1*K+tr) 0    ( 2*K-tr) 0
+ ( 2*K+tr) 0    ( 3*K-tr) 0
+ ( 3*K+tr) 0    ( 4*K-tr) 0
+ ( 4*K+tr) 0    ( 5*K-tr) 0
+ ( 5*K+tr) 0    ( 6*K-tr) 0
+ ( 6*K+tr) 0    ( 7*K-tr) 0
+ ( 7*K+tr) 0    ( 8*K-tr) 0
+ ( 8*K+tr) 0    ( 9*K-tr) 0
+ ( 9*K+tr) 0    (10*K-tr) 0
+ (10*K+tr) 0    (11*K-tr) 0
+ (11*K+tr) 0    (12*K-tr) 0
+ (12*K+tr) 0    (13*K-tr) 0
+ (13*K+tr) 0    (14*K-tr) 0
+ (14*K+tr) 0    (15*K-tr) 0
+ (15*K+tr) 0    (16*K-tr) 0
+ (16*K+tr) 0    (17*K-tr) 0
+ (17*K+tr) 0    (18*K-tr) 0
+ (18*K+tr) 0    (19*K-tr) 0
+ (19*K+tr) 0    (20*K-tr) 0
+ (20*K+tr) 0    (21*K-tr) 0
+ (21*K+tr) 0    (22*K-tr) 0
+ (22*K+tr) 0    (23*K-tr) 0
+ (23*K+tr) 0    (24*K-tr) 0
+ (24*K+tr) 0    (25*K-tr) 0
+ (25*K+tr) 0    (26*K-tr) 0
+ (26*K+tr) 0    (27*K-tr) 0
+ (27*K+tr) 0    (28*K-tr) 0
+ (28*K+tr) 0    (29*K-tr) 0
+ (29*K+tr) 0    (30*K-tr) 0
+ (30*K+tr) 0    (31*K-tr) 0
+ (31*K+tr) 0    (32*K-tr) 0
+ (32*K+tr) 0    (33*K-tr) 0
+ (33*K+tr) 0    (34*K-tr) 0
+ (34*K+tr) 0    (35*K-tr) 0
+ (35*K+tr) 0    (36*K-tr) 0
+ (36*K+tr) 0    (37*K-tr) 0
+ (37*K+tr) 0    (38*K-tr) 0
+ (38*K+tr) 0    (39*K-tr) 0
+ (39*K+tr) 0    (40*K-tr) 0
+ (40*K+tr) 0    (41*K-tr) 0
+ (41*K+tr) 0    (42*K-tr) 0
+ (42*K+tr) 0    (43*K-tr) 0
+ (43*K+tr) 0    (44*K-tr) 0
+ (44*K+tr) 0    (45*K-tr) 0
+ (45*K+tr) 0    (46*K-tr) 0
+ (46*K+tr) 0    (47*K-tr) 0
+ (47*K+tr) 0    (48*K-tr) 0
+ (48*K+tr) 0    (49*K-tr) 0
+ (49*K+tr) 0    (50*K-tr) 0
+ (50*K+tr) 0    (51*K-tr) 0
+ (51*K+tr) 0    (52*K-tr) 0
+ (52*K+tr) 0    (53*K-tr) 0
+ (53*K+tr) 0    (54*K-tr) 0
+ (54*K+tr) 0    (55*K-tr) 0
+ (55*K+tr) 0    (56*K-tr) 0
+ (56*K+tr) 0    (57*K-tr) 0
+ (57*K+tr) 0    (58*K-tr) 0
+ (58*K+tr) 0    (59*K-tr) 0
+ (59*K+tr) 0    (60*K-tr) 0
+ (60*K+tr) 0    (61*K-tr) 0
+ (61*K+tr) 0    (62*K-tr) 0
+ (62*K+tr) 0    (63*K-tr) 0
+ (63*K+tr) 0    (64*K-tr) 0
+ (64*K+tr) 0    (65*K-tr) 0
+ (65*K+tr) 0    (66*K-tr) 0
+ (66*K+tr) 0    (67*K-tr) 0
+ (67*K+tr) 0    (68*K-tr) 0
+ (68*K+tr) 0    (69*K-tr) 0
+ (69*K+tr) 0    (70*K-tr) 0
+ (70*K+tr) 0    (71*K-tr) 0
+ (71*K+tr) 0    (72*K-tr) 0
+ (72*K+tr) 0    (73*K-tr) 0
+ (73*K+tr) 0    (74*K-tr) 0
+ (74*K+tr) 0    (75*K-tr) 0
+ (75*K+tr) 0    (76*K-tr) 0
+ (76*K+tr) 0    (77*K-tr) 0
+ (77*K+tr) 0    (78*K-tr) 0
+ (78*K+tr) 0    (79*K-tr) 0
+ (79*K+tr) 0    (80*K-tr) 0
+ (80*K+tr) 0    (81*K-tr) 0
+ (81*K+tr) 0    (82*K-tr) 0
+ (82*K+tr) 0    (83*K-tr) 0
+ (83*K+tr) 0    (84*K-tr) 0
+ (84*K+tr) 0    (85*K-tr) 0
+ (85*K+tr) 0    (86*K-tr) 0
+ (86*K+tr) 0    (87*K-tr) 0
+ (87*K+tr) 0    (88*K-tr) 0
+ (88*K+tr) 0    (89*K-tr) 0
+ (89*K+tr) 0    (90*K-tr) 0
+ (90*K+tr) 0    (91*K-tr) 0
+ (91*K+tr) 0    (92*K-tr) 0
+ (92*K+tr) 0    (93*K-tr) 0
+ (93*K+tr) 0    (94*K-tr) 0
+ (94*K+tr) 0    (95*K-tr) 0
+ (95*K+tr) 0    (96*K-tr) 0
+ (96*K+tr) 0    (97*K-tr) 0
+ (97*K+tr) 0    (98*K-tr) 0
+ (98*K+tr) 0    (99*K-tr) 0
+ (99*K+tr) 0    (100*K-tr) 0
+ (100*K+tr) 0    (101*K-tr) 0
+ (101*K+tr) 0    (102*K-tr) 0
+ (102*K+tr) 0    (103*K-tr) 0
+ (103*K+tr) 0    (104*K-tr) 0
+ (104*K+tr) 0    (105*K-tr) 0
+ (105*K+tr) 0    (106*K-tr) 0
+ (106*K+tr) 0    (107*K-tr) 0
+ (107*K+tr) 0    (108*K-tr) 0
+ (108*K+tr) 0    (109*K-tr) 0
+ (109*K+tr) 0    (110*K-tr) 0
+ (110*K+tr) 0    (111*K-tr) 0
+ (111*K+tr) 0    (112*K-tr) 0
+ (112*K+tr) 0    (113*K-tr) 0
+ (113*K+tr) 0    (114*K-tr) 0
+ (114*K+tr) 0    (115*K-tr) 0
+ (115*K+tr) 0    (116*K-tr) 0
+ (116*K+tr) 0    (117*K-tr) 0
+ (117*K+tr) 0    (118*K-tr) 0
+ (118*K+tr) 0    (119*K-tr) 0
+ (119*K+tr) 0    (120*K-tr) 0
+ (120*K+tr) 0    (121*K-tr) 0
+ (121*K+tr) 0    (122*K-tr) 0
+ (122*K+tr) 0    (123*K-tr) 0
+ (123*K+tr) 0    (124*K-tr) 0
+ (124*K+tr) 0    (125*K-tr) 0
+ (125*K+tr) 0    (126*K-tr) 0
+ (126*K+tr) 0    (127*K-tr) 0
+ (127*K+tr) 0    (128*K-tr) 0
+ (128*K+tr) 0    (129*K-tr) 0
+ (129*K+tr) 0    (130*K-tr) 0
+ (130*K+tr) 0    (131*K-tr) 0
+ (131*K+tr) 0    (132*K-tr) 0
+ (132*K+tr) 0    (133*K-tr) 0
+ (133*K+tr) 0    (134*K-tr) 0
+ (134*K+tr) 0    (135*K-tr) 0
+ (135*K+tr) 0    (136*K-tr) 0
+ (136*K+tr) 0    (137*K-tr) 0
+ (137*K+tr) 0    (138*K-tr) 0
+ (138*K+tr) 0    (139*K-tr) 0
+ (139*K+tr) 0    (140*K-tr) 0
+ (140*K+tr) 0    (141*K-tr) 0
+ (141*K+tr) 0    (142*K-tr) 0
+ (142*K+tr) 0    (143*K-tr) 0
+ (143*K+tr) 0    (144*K-tr) 0
+ (144*K+tr) 0    (145*K-tr) 0
+ (145*K+tr) 0    (146*K-tr) 0
+ (146*K+tr) 0    (147*K-tr) 0
+ (147*K+ 0*L+tr) 0    (147*K+ 1*L-tr) 0
+ (147*K+ 1*L+tr) 0    (147*K+ 2*L-tr) 0
+ (147*K+ 2*L+tr) 0    (147*K+ 3*L-tr) 0
+ (147*K+ 3*L+tr) 0    (147*K+ 4*L-tr) 0
+ (147*K+ 4*L+tr) 0    (147*K+ 5*L-tr) 0
+ (147*K+ 5*L+tr) 0    (147*K+ 6*L-tr) 0
+ (147*K+ 6*L+tr) 0    (147*K+ 7*L-tr) 0
+ (147*K+ 7*L+tr) 0    (147*K+ 8*L-tr) 0
+ (147*K+ 8*L+tr) 0    (147*K+ 9*L-tr) 0
+ (147*K+ 9*L+tr) 0    (147*K+10*L-tr) 0
+ (147*K+10*L+tr) 0    (147*K+11*L-tr) 0
+ (147*K+11*L+tr) 0    (147*K+12*L-tr) 0
+ (147*K+12*L+tr) 0    (147*K+13*L-tr) 0
+ (147*K+13*L+tr) 0    (147*K+14*L-tr) 0
+ ]
vBitLine1 (BitLine1 0) vsource type=pwl wave=\[
+ ( 0*K   ) 0    ( 1*K-tr) 0
+ ( 1*K+tr) 0    ( 2*K-tr) 0
+ ( 2*K+tr) 0    ( 3*K-tr) 0
+ ( 3*K+tr) 0    ( 4*K-tr) 0
+ ( 4*K+tr) 0    ( 5*K-tr) 0
+ ( 5*K+tr) 0    ( 6*K-tr) 0
+ ( 6*K+tr) 0    ( 7*K-tr) 0
+ ( 7*K+tr) 0    ( 8*K-tr) 0
+ ( 8*K+tr) 0    ( 9*K-tr) 0
+ ( 9*K+tr) 0    (10*K-tr) 0
+ (10*K+tr) 0    (11*K-tr) 0
+ (11*K+tr) 0    (12*K-tr) 0
+ (12*K+tr) 0    (13*K-tr) 0
+ (13*K+tr) 0    (14*K-tr) 0
+ (14*K+tr) 0    (15*K-tr) 0
+ (15*K+tr) 0    (16*K-tr) 0
+ (16*K+tr) 0    (17*K-tr) 0
+ (17*K+tr) VDD  (18*K-tr) VDD
+ (18*K+tr) 0    (19*K-tr) 0
+ (19*K+tr) 0    (20*K-tr) 0
+ (20*K+tr) 0    (21*K-tr) 0
+ (21*K+tr) 0    (22*K-tr) 0
+ (22*K+tr) 0    (23*K-tr) 0
+ (23*K+tr) 0    (24*K-tr) 0
+ (24*K+tr) 0    (25*K-tr) 0
+ (25*K+tr) 0    (26*K-tr) 0
+ (26*K+tr) VDD  (27*K-tr) VDD
+ (27*K+tr) 0    (28*K-tr) 0
+ (28*K+tr) 0    (29*K-tr) 0
+ (29*K+tr) VDD  (30*K-tr) VDD
+ (30*K+tr) 0    (31*K-tr) 0
+ (31*K+tr) 0    (32*K-tr) 0
+ (32*K+tr) 0    (33*K-tr) 0
+ (33*K+tr) 0    (34*K-tr) 0
+ (34*K+tr) 0    (35*K-tr) 0
+ (35*K+tr) 0    (36*K-tr) 0
+ (36*K+tr) 0    (37*K-tr) 0
+ (37*K+tr) 0    (38*K-tr) 0
+ (38*K+tr) 0    (39*K-tr) 0
+ (39*K+tr) 0    (40*K-tr) 0
+ (40*K+tr) 0    (41*K-tr) 0
+ (41*K+tr) 0    (42*K-tr) 0
+ (42*K+tr) 0    (43*K-tr) 0
+ (43*K+tr) 0    (44*K-tr) 0
+ (44*K+tr) 0    (45*K-tr) 0
+ (45*K+tr) 0    (46*K-tr) 0
+ (46*K+tr) 0    (47*K-tr) 0
+ (47*K+tr) 0    (48*K-tr) 0
+ (48*K+tr) 0    (49*K-tr) 0
+ (49*K+tr) 0    (50*K-tr) 0
+ (50*K+tr) 0    (51*K-tr) 0
+ (51*K+tr) 0    (52*K-tr) 0
+ (52*K+tr) 0    (53*K-tr) 0
+ (53*K+tr) 0    (54*K-tr) 0
+ (54*K+tr) 0    (55*K-tr) 0
+ (55*K+tr) 0    (56*K-tr) 0
+ (56*K+tr) 0    (57*K-tr) 0
+ (57*K+tr) 0    (58*K-tr) 0
+ (58*K+tr) 0    (59*K-tr) 0
+ (59*K+tr) 0    (60*K-tr) 0
+ (60*K+tr) 0    (61*K-tr) 0
+ (61*K+tr) 0    (62*K-tr) 0
+ (62*K+tr) 0    (63*K-tr) 0
+ (63*K+tr) 0    (64*K-tr) 0
+ (64*K+tr) 0    (65*K-tr) 0
+ (65*K+tr) 0    (66*K-tr) 0
+ (66*K+tr) 0    (67*K-tr) 0
+ (67*K+tr) 0    (68*K-tr) 0
+ (68*K+tr) 0    (69*K-tr) 0
+ (69*K+tr) 0    (70*K-tr) 0
+ (70*K+tr) 0    (71*K-tr) 0
+ (71*K+tr) 0    (72*K-tr) 0
+ (72*K+tr) 0    (73*K-tr) 0
+ (73*K+tr) 0    (74*K-tr) 0
+ (74*K+tr) 0    (75*K-tr) 0
+ (75*K+tr) 0    (76*K-tr) 0
+ (76*K+tr) 0    (77*K-tr) 0
+ (77*K+tr) VDD  (78*K-tr) VDD
+ (78*K+tr) 0    (79*K-tr) 0
+ (79*K+tr) 0    (80*K-tr) 0
+ (80*K+tr) 0    (81*K-tr) 0
+ (81*K+tr) 0    (82*K-tr) 0
+ (82*K+tr) 0    (83*K-tr) 0
+ (83*K+tr) 0    (84*K-tr) 0
+ (84*K+tr) 0    (85*K-tr) 0
+ (85*K+tr) 0    (86*K-tr) 0
+ (86*K+tr) VDD  (87*K-tr) VDD
+ (87*K+tr) 0    (88*K-tr) 0
+ (88*K+tr) 0    (89*K-tr) 0
+ (89*K+tr) 0    (90*K-tr) 0
+ (90*K+tr) 0    (91*K-tr) 0
+ (91*K+tr) 0    (92*K-tr) 0
+ (92*K+tr) 0    (93*K-tr) 0
+ (93*K+tr) 0    (94*K-tr) 0
+ (94*K+tr) 0    (95*K-tr) 0
+ (95*K+tr) VDD  (96*K-tr) VDD
+ (96*K+tr) 0    (97*K-tr) 0
+ (97*K+tr) 0    (98*K-tr) 0
+ (98*K+tr) 0    (99*K-tr) 0
+ (99*K+tr) 0    (100*K-tr) 0
+ (100*K+tr) 0    (101*K-tr) 0
+ (101*K+tr) 0    (102*K-tr) 0
+ (102*K+tr) 0    (103*K-tr) 0
+ (103*K+tr) 0    (104*K-tr) 0
+ (104*K+tr) 0    (105*K-tr) 0
+ (105*K+tr) 0    (106*K-tr) 0
+ (106*K+tr) VDD  (107*K-tr) VDD
+ (107*K+tr) 0    (108*K-tr) 0
+ (108*K+tr) 0    (109*K-tr) 0
+ (109*K+tr) VDD  (110*K-tr) VDD
+ (110*K+tr) 0    (111*K-tr) 0
+ (111*K+tr) 0    (112*K-tr) 0
+ (112*K+tr) 0    (113*K-tr) 0
+ (113*K+tr) 0    (114*K-tr) 0
+ (114*K+tr) 0    (115*K-tr) 0
+ (115*K+tr) VDD  (116*K-tr) VDD
+ (116*K+tr) 0    (117*K-tr) 0
+ (117*K+tr) 0    (118*K-tr) 0
+ (118*K+tr) VDD  (119*K-tr) VDD
+ (119*K+tr) 0    (120*K-tr) 0
+ (120*K+tr) 0    (121*K-tr) 0
+ (121*K+tr) 0    (122*K-tr) 0
+ (122*K+tr) 0    (123*K-tr) 0
+ (123*K+tr) 0    (124*K-tr) 0
+ (124*K+tr) VDD  (125*K-tr) VDD
+ (125*K+tr) 0    (126*K-tr) 0
+ (126*K+tr) 0    (127*K-tr) 0
+ (127*K+tr) VDD  (128*K-tr) VDD
+ (128*K+tr) 0    (129*K-tr) 0
+ (129*K+tr) 0    (130*K-tr) 0
+ (130*K+tr) 0    (131*K-tr) 0
+ (131*K+tr) 0    (132*K-tr) 0
+ (132*K+tr) 0    (133*K-tr) 0
+ (133*K+tr) VDD  (134*K-tr) VDD
+ (134*K+tr) 0    (135*K-tr) 0
+ (135*K+tr) 0    (136*K-tr) 0
+ (136*K+tr) VDD  (137*K-tr) VDD
+ (137*K+tr) 0    (138*K-tr) 0
+ (138*K+tr) 0    (139*K-tr) 0
+ (139*K+tr) 0    (140*K-tr) 0
+ (140*K+tr) 0    (141*K-tr) 0
+ (141*K+tr) 0    (142*K-tr) 0
+ (142*K+tr) 0    (143*K-tr) 0
+ (143*K+tr) 0    (144*K-tr) 0
+ (144*K+tr) 0    (145*K-tr) 0
+ (145*K+tr) 0    (146*K-tr) 0
+ (146*K+tr) 0    (147*K-tr) 0
+ (147*K+ 0*L+tr) 0    (147*K+ 1*L-tr) 0
+ (147*K+ 1*L+tr) 0    (147*K+ 2*L-tr) 0
+ (147*K+ 2*L+tr) 0    (147*K+ 3*L-tr) 0
+ (147*K+ 3*L+tr) 0    (147*K+ 4*L-tr) 0
+ (147*K+ 4*L+tr) 0    (147*K+ 5*L-tr) 0
+ (147*K+ 5*L+tr) 0    (147*K+ 6*L-tr) 0
+ (147*K+ 6*L+tr) 0    (147*K+ 7*L-tr) 0
+ (147*K+ 7*L+tr) 0    (147*K+ 8*L-tr) 0
+ (147*K+ 8*L+tr) 0    (147*K+ 9*L-tr) 0
+ (147*K+ 9*L+tr) 0    (147*K+10*L-tr) 0
+ (147*K+10*L+tr) 0    (147*K+11*L-tr) 0
+ (147*K+11*L+tr) 0    (147*K+12*L-tr) 0
+ (147*K+12*L+tr) 0    (147*K+13*L-tr) 0
+ (147*K+13*L+tr) 0    (147*K+14*L-tr) 0
+ ]
vBitLine_1 (BitLine_1 0) vsource type=pwl wave=\[
+ ( 0*K   ) VDD  ( 1*K-tr) VDD
+ ( 1*K+tr) VDD  ( 2*K-tr) VDD
+ ( 2*K+tr) VDD  ( 3*K-tr) VDD
+ ( 3*K+tr) VDD  ( 4*K-tr) VDD
+ ( 4*K+tr) VDD  ( 5*K-tr) VDD
+ ( 5*K+tr) VDD  ( 6*K-tr) VDD
+ ( 6*K+tr) VDD  ( 7*K-tr) VDD
+ ( 7*K+tr) VDD  ( 8*K-tr) VDD
+ ( 8*K+tr) VDD  ( 9*K-tr) VDD
+ ( 9*K+tr) VDD  (10*K-tr) VDD
+ (10*K+tr) VDD  (11*K-tr) VDD
+ (11*K+tr) VDD  (12*K-tr) VDD
+ (12*K+tr) VDD  (13*K-tr) VDD
+ (13*K+tr) VDD  (14*K-tr) VDD
+ (14*K+tr) VDD  (15*K-tr) VDD
+ (15*K+tr) VDD  (16*K-tr) VDD
+ (16*K+tr) VDD  (17*K-tr) VDD
+ (17*K+tr) 0    (18*K-tr) 0
+ (18*K+tr) VDD  (19*K-tr) VDD
+ (19*K+tr) VDD  (20*K-tr) VDD
+ (20*K+tr) VDD  (21*K-tr) VDD
+ (21*K+tr) VDD  (22*K-tr) VDD
+ (22*K+tr) VDD  (23*K-tr) VDD
+ (23*K+tr) VDD  (24*K-tr) VDD
+ (24*K+tr) VDD  (25*K-tr) VDD
+ (25*K+tr) VDD  (26*K-tr) VDD
+ (26*K+tr) 0    (27*K-tr) 0
+ (27*K+tr) VDD  (28*K-tr) VDD
+ (28*K+tr) VDD  (29*K-tr) VDD
+ (29*K+tr) 0    (30*K-tr) 0
+ (30*K+tr) VDD  (31*K-tr) VDD
+ (31*K+tr) VDD  (32*K-tr) VDD
+ (32*K+tr) VDD  (33*K-tr) VDD
+ (33*K+tr) VDD  (34*K-tr) VDD
+ (34*K+tr) VDD  (35*K-tr) VDD
+ (35*K+tr) VDD  (36*K-tr) VDD
+ (36*K+tr) VDD  (37*K-tr) VDD
+ (37*K+tr) VDD  (38*K-tr) VDD
+ (38*K+tr) VDD  (39*K-tr) VDD
+ (39*K+tr) VDD  (40*K-tr) VDD
+ (40*K+tr) VDD  (41*K-tr) VDD
+ (41*K+tr) VDD  (42*K-tr) VDD
+ (42*K+tr) VDD  (43*K-tr) VDD
+ (43*K+tr) VDD  (44*K-tr) VDD
+ (44*K+tr) VDD  (45*K-tr) VDD
+ (45*K+tr) VDD  (46*K-tr) VDD
+ (46*K+tr) VDD  (47*K-tr) VDD
+ (47*K+tr) VDD  (48*K-tr) VDD
+ (48*K+tr) VDD  (49*K-tr) VDD
+ (49*K+tr) VDD  (50*K-tr) VDD
+ (50*K+tr) VDD  (51*K-tr) VDD
+ (51*K+tr) VDD  (52*K-tr) VDD
+ (52*K+tr) VDD  (53*K-tr) VDD
+ (53*K+tr) VDD  (54*K-tr) VDD
+ (54*K+tr) VDD  (55*K-tr) VDD
+ (55*K+tr) VDD  (56*K-tr) VDD
+ (56*K+tr) VDD  (57*K-tr) VDD
+ (57*K+tr) VDD  (58*K-tr) VDD
+ (58*K+tr) VDD  (59*K-tr) VDD
+ (59*K+tr) VDD  (60*K-tr) VDD
+ (60*K+tr) VDD  (61*K-tr) VDD
+ (61*K+tr) VDD  (62*K-tr) VDD
+ (62*K+tr) VDD  (63*K-tr) VDD
+ (63*K+tr) VDD  (64*K-tr) VDD
+ (64*K+tr) VDD  (65*K-tr) VDD
+ (65*K+tr) VDD  (66*K-tr) VDD
+ (66*K+tr) VDD  (67*K-tr) VDD
+ (67*K+tr) VDD  (68*K-tr) VDD
+ (68*K+tr) VDD  (69*K-tr) VDD
+ (69*K+tr) VDD  (70*K-tr) VDD
+ (70*K+tr) VDD  (71*K-tr) VDD
+ (71*K+tr) VDD  (72*K-tr) VDD
+ (72*K+tr) VDD  (73*K-tr) VDD
+ (73*K+tr) VDD  (74*K-tr) VDD
+ (74*K+tr) VDD  (75*K-tr) VDD
+ (75*K+tr) VDD  (76*K-tr) VDD
+ (76*K+tr) VDD  (77*K-tr) VDD
+ (77*K+tr) 0    (78*K-tr) 0
+ (78*K+tr) VDD  (79*K-tr) VDD
+ (79*K+tr) VDD  (80*K-tr) VDD
+ (80*K+tr) VDD  (81*K-tr) VDD
+ (81*K+tr) VDD  (82*K-tr) VDD
+ (82*K+tr) VDD  (83*K-tr) VDD
+ (83*K+tr) VDD  (84*K-tr) VDD
+ (84*K+tr) VDD  (85*K-tr) VDD
+ (85*K+tr) VDD  (86*K-tr) VDD
+ (86*K+tr) 0    (87*K-tr) 0
+ (87*K+tr) VDD  (88*K-tr) VDD
+ (88*K+tr) VDD  (89*K-tr) VDD
+ (89*K+tr) VDD  (90*K-tr) VDD
+ (90*K+tr) VDD  (91*K-tr) VDD
+ (91*K+tr) VDD  (92*K-tr) VDD
+ (92*K+tr) VDD  (93*K-tr) VDD
+ (93*K+tr) VDD  (94*K-tr) VDD
+ (94*K+tr) VDD  (95*K-tr) VDD
+ (95*K+tr) 0    (96*K-tr) 0
+ (96*K+tr) VDD  (97*K-tr) VDD
+ (97*K+tr) VDD  (98*K-tr) VDD
+ (98*K+tr) VDD  (99*K-tr) VDD
+ (99*K+tr) VDD  (100*K-tr) VDD
+ (100*K+tr) VDD  (101*K-tr) VDD
+ (101*K+tr) VDD  (102*K-tr) VDD
+ (102*K+tr) VDD  (103*K-tr) VDD
+ (103*K+tr) VDD  (104*K-tr) VDD
+ (104*K+tr) VDD  (105*K-tr) VDD
+ (105*K+tr) VDD  (106*K-tr) VDD
+ (106*K+tr) 0    (107*K-tr) 0
+ (107*K+tr) VDD  (108*K-tr) VDD
+ (108*K+tr) VDD  (109*K-tr) VDD
+ (109*K+tr) 0    (110*K-tr) 0
+ (110*K+tr) VDD  (111*K-tr) VDD
+ (111*K+tr) VDD  (112*K-tr) VDD
+ (112*K+tr) VDD  (113*K-tr) VDD
+ (113*K+tr) VDD  (114*K-tr) VDD
+ (114*K+tr) VDD  (115*K-tr) VDD
+ (115*K+tr) 0    (116*K-tr) 0
+ (116*K+tr) VDD  (117*K-tr) VDD
+ (117*K+tr) VDD  (118*K-tr) VDD
+ (118*K+tr) 0    (119*K-tr) 0
+ (119*K+tr) VDD  (120*K-tr) VDD
+ (120*K+tr) VDD  (121*K-tr) VDD
+ (121*K+tr) VDD  (122*K-tr) VDD
+ (122*K+tr) VDD  (123*K-tr) VDD
+ (123*K+tr) VDD  (124*K-tr) VDD
+ (124*K+tr) 0    (125*K-tr) 0
+ (125*K+tr) VDD  (126*K-tr) VDD
+ (126*K+tr) VDD  (127*K-tr) VDD
+ (127*K+tr) 0    (128*K-tr) 0
+ (128*K+tr) VDD  (129*K-tr) VDD
+ (129*K+tr) VDD  (130*K-tr) VDD
+ (130*K+tr) VDD  (131*K-tr) VDD
+ (131*K+tr) VDD  (132*K-tr) VDD
+ (132*K+tr) VDD  (133*K-tr) VDD
+ (133*K+tr) 0    (134*K-tr) 0
+ (134*K+tr) VDD  (135*K-tr) VDD
+ (135*K+tr) VDD  (136*K-tr) VDD
+ (136*K+tr) 0    (137*K-tr) 0
+ (137*K+tr) VDD  (138*K-tr) VDD
+ (138*K+tr) VDD  (139*K-tr) VDD
+ (139*K+tr) VDD  (140*K-tr) VDD
+ (140*K+tr) VDD  (141*K-tr) VDD
+ (141*K+tr) VDD  (142*K-tr) VDD
+ (142*K+tr) VDD  (143*K-tr) VDD
+ (143*K+tr) VDD  (144*K-tr) VDD
+ (144*K+tr) VDD  (145*K-tr) VDD
+ (145*K+tr) VDD  (146*K-tr) VDD
+ (146*K+tr) VDD  (147*K-tr) VDD
+ (147*K+ 0*L+tr) VDD  (147*K+ 1*L-tr) VDD
+ (147*K+ 1*L+tr) VDD  (147*K+ 2*L-tr) VDD
+ (147*K+ 2*L+tr) VDD  (147*K+ 3*L-tr) VDD
+ (147*K+ 3*L+tr) VDD  (147*K+ 4*L-tr) VDD
+ (147*K+ 4*L+tr) VDD  (147*K+ 5*L-tr) VDD
+ (147*K+ 5*L+tr) VDD  (147*K+ 6*L-tr) VDD
+ (147*K+ 6*L+tr) VDD  (147*K+ 7*L-tr) VDD
+ (147*K+ 7*L+tr) VDD  (147*K+ 8*L-tr) VDD
+ (147*K+ 8*L+tr) VDD  (147*K+ 9*L-tr) VDD
+ (147*K+ 9*L+tr) VDD  (147*K+10*L-tr) VDD
+ (147*K+10*L+tr) VDD  (147*K+11*L-tr) VDD
+ (147*K+11*L+tr) VDD  (147*K+12*L-tr) VDD
+ (147*K+12*L+tr) VDD  (147*K+13*L-tr) VDD
+ (147*K+13*L+tr) VDD  (147*K+14*L-tr) VDD
+ ]
vBitLine2 (BitLine2 0) vsource type=pwl wave=\[
+ ( 0*K   ) 0    ( 1*K-tr) 0
+ ( 1*K+tr) 0    ( 2*K-tr) 0
+ ( 2*K+tr) 0    ( 3*K-tr) 0
+ ( 3*K+tr) 0    ( 4*K-tr) 0
+ ( 4*K+tr) 0    ( 5*K-tr) 0
+ ( 5*K+tr) 0    ( 6*K-tr) 0
+ ( 6*K+tr) 0    ( 7*K-tr) 0
+ ( 7*K+tr) 0    ( 8*K-tr) 0
+ ( 8*K+tr) 0    ( 9*K-tr) 0
+ ( 9*K+tr) 0    (10*K-tr) 0
+ (10*K+tr) 0    (11*K-tr) 0
+ (11*K+tr) 0    (12*K-tr) 0
+ (12*K+tr) 0    (13*K-tr) 0
+ (13*K+tr) 0    (14*K-tr) 0
+ (14*K+tr) VDD  (15*K-tr) VDD
+ (15*K+tr) 0    (16*K-tr) 0
+ (16*K+tr) 0    (17*K-tr) 0
+ (17*K+tr) 0    (18*K-tr) 0
+ (18*K+tr) 0    (19*K-tr) 0
+ (19*K+tr) 0    (20*K-tr) 0
+ (20*K+tr) VDD  (21*K-tr) VDD
+ (21*K+tr) 0    (22*K-tr) 0
+ (22*K+tr) 0    (23*K-tr) 0
+ (23*K+tr) VDD  (24*K-tr) VDD
+ (24*K+tr) 0    (25*K-tr) 0
+ (25*K+tr) 0    (26*K-tr) 0
+ (26*K+tr) 0    (27*K-tr) 0
+ (27*K+tr) 0    (28*K-tr) 0
+ (28*K+tr) 0    (29*K-tr) 0
+ (29*K+tr) 0    (30*K-tr) 0
+ (30*K+tr) 0    (31*K-tr) 0
+ (31*K+tr) 0    (32*K-tr) 0
+ (32*K+tr) VDD  (33*K-tr) VDD
+ (33*K+tr) 0    (34*K-tr) 0
+ (34*K+tr) 0    (35*K-tr) 0
+ (35*K+tr) VDD  (36*K-tr) VDD
+ (36*K+tr) 0    (37*K-tr) 0
+ (37*K+tr) 0    (38*K-tr) 0
+ (38*K+tr) VDD  (39*K-tr) VDD
+ (39*K+tr) 0    (40*K-tr) 0
+ (40*K+tr) 0    (41*K-tr) 0
+ (41*K+tr) 0    (42*K-tr) 0
+ (42*K+tr) 0    (43*K-tr) 0
+ (43*K+tr) 0    (44*K-tr) 0
+ (44*K+tr) 0    (45*K-tr) 0
+ (45*K+tr) 0    (46*K-tr) 0
+ (46*K+tr) 0    (47*K-tr) 0
+ (47*K+tr) 0    (48*K-tr) 0
+ (48*K+tr) 0    (49*K-tr) 0
+ (49*K+tr) 0    (50*K-tr) 0
+ (50*K+tr) 0    (51*K-tr) 0
+ (51*K+tr) 0    (52*K-tr) 0
+ (52*K+tr) 0    (53*K-tr) 0
+ (53*K+tr) 0    (54*K-tr) 0
+ (54*K+tr) 0    (55*K-tr) 0
+ (55*K+tr) 0    (56*K-tr) 0
+ (56*K+tr) 0    (57*K-tr) 0
+ (57*K+tr) 0    (58*K-tr) 0
+ (58*K+tr) 0    (59*K-tr) 0
+ (59*K+tr) 0    (60*K-tr) 0
+ (60*K+tr) 0    (61*K-tr) 0
+ (61*K+tr) 0    (62*K-tr) 0
+ (62*K+tr) 0    (63*K-tr) 0
+ (63*K+tr) 0    (64*K-tr) 0
+ (64*K+tr) 0    (65*K-tr) 0
+ (65*K+tr) 0    (66*K-tr) 0
+ (66*K+tr) 0    (67*K-tr) 0
+ (67*K+tr) 0    (68*K-tr) 0
+ (68*K+tr) 0    (69*K-tr) 0
+ (69*K+tr) 0    (70*K-tr) 0
+ (70*K+tr) 0    (71*K-tr) 0
+ (71*K+tr) 0    (72*K-tr) 0
+ (72*K+tr) 0    (73*K-tr) 0
+ (73*K+tr) 0    (74*K-tr) 0
+ (74*K+tr) 0    (75*K-tr) 0
+ (75*K+tr) VDD  (76*K-tr) VDD
+ (76*K+tr) 0    (77*K-tr) 0
+ (77*K+tr) VDD  (78*K-tr) VDD
+ (78*K+tr) 0    (79*K-tr) 0
+ (79*K+tr) 0    (80*K-tr) 0
+ (80*K+tr) 0    (81*K-tr) 0
+ (81*K+tr) 0    (82*K-tr) 0
+ (82*K+tr) 0    (83*K-tr) 0
+ (83*K+tr) 0    (84*K-tr) 0
+ (84*K+tr) VDD  (85*K-tr) VDD
+ (85*K+tr) 0    (86*K-tr) 0
+ (86*K+tr) VDD  (87*K-tr) VDD
+ (87*K+tr) 0    (88*K-tr) 0
+ (88*K+tr) 0    (89*K-tr) 0
+ (89*K+tr) 0    (90*K-tr) 0
+ (90*K+tr) 0    (91*K-tr) 0
+ (91*K+tr) 0    (92*K-tr) 0
+ (92*K+tr) 0    (93*K-tr) 0
+ (93*K+tr) VDD  (94*K-tr) VDD
+ (94*K+tr) 0    (95*K-tr) 0
+ (95*K+tr) VDD  (96*K-tr) VDD
+ (96*K+tr) 0    (97*K-tr) 0
+ (97*K+tr) 0    (98*K-tr) 0
+ (98*K+tr) 0    (99*K-tr) 0
+ (99*K+tr) 0    (100*K-tr) 0
+ (100*K+tr) 0    (101*K-tr) 0
+ (101*K+tr) 0    (102*K-tr) 0
+ (102*K+tr) 0    (103*K-tr) 0
+ (103*K+tr) 0    (104*K-tr) 0
+ (104*K+tr) 0    (105*K-tr) 0
+ (105*K+tr) 0    (106*K-tr) 0
+ (106*K+tr) VDD  (107*K-tr) VDD
+ (107*K+tr) 0    (108*K-tr) 0
+ (108*K+tr) 0    (109*K-tr) 0
+ (109*K+tr) VDD  (110*K-tr) VDD
+ (110*K+tr) 0    (111*K-tr) 0
+ (111*K+tr) 0    (112*K-tr) 0
+ (112*K+tr) 0    (113*K-tr) 0
+ (113*K+tr) 0    (114*K-tr) 0
+ (114*K+tr) 0    (115*K-tr) 0
+ (115*K+tr) VDD  (116*K-tr) VDD
+ (116*K+tr) 0    (117*K-tr) 0
+ (117*K+tr) 0    (118*K-tr) 0
+ (118*K+tr) VDD  (119*K-tr) VDD
+ (119*K+tr) 0    (120*K-tr) 0
+ (120*K+tr) 0    (121*K-tr) 0
+ (121*K+tr) 0    (122*K-tr) 0
+ (122*K+tr) 0    (123*K-tr) 0
+ (123*K+tr) 0    (124*K-tr) 0
+ (124*K+tr) VDD  (125*K-tr) VDD
+ (125*K+tr) 0    (126*K-tr) 0
+ (126*K+tr) 0    (127*K-tr) 0
+ (127*K+tr) VDD  (128*K-tr) VDD
+ (128*K+tr) 0    (129*K-tr) 0
+ (129*K+tr) 0    (130*K-tr) 0
+ (130*K+tr) 0    (131*K-tr) 0
+ (131*K+tr) 0    (132*K-tr) 0
+ (132*K+tr) 0    (133*K-tr) 0
+ (133*K+tr) VDD  (134*K-tr) VDD
+ (134*K+tr) 0    (135*K-tr) 0
+ (135*K+tr) 0    (136*K-tr) 0
+ (136*K+tr) VDD  (137*K-tr) VDD
+ (137*K+tr) 0    (138*K-tr) 0
+ (138*K+tr) 0    (139*K-tr) 0
+ (139*K+tr) 0    (140*K-tr) 0
+ (140*K+tr) 0    (141*K-tr) 0
+ (141*K+tr) 0    (142*K-tr) 0
+ (142*K+tr) 0    (143*K-tr) 0
+ (143*K+tr) 0    (144*K-tr) 0
+ (144*K+tr) 0    (145*K-tr) 0
+ (145*K+tr) 0    (146*K-tr) 0
+ (146*K+tr) 0    (147*K-tr) 0
+ (147*K+ 0*L+tr) 0    (147*K+ 1*L-tr) 0
+ (147*K+ 1*L+tr) 0    (147*K+ 2*L-tr) 0
+ (147*K+ 2*L+tr) 0    (147*K+ 3*L-tr) 0
+ (147*K+ 3*L+tr) 0    (147*K+ 4*L-tr) 0
+ (147*K+ 4*L+tr) 0    (147*K+ 5*L-tr) 0
+ (147*K+ 5*L+tr) 0    (147*K+ 6*L-tr) 0
+ (147*K+ 6*L+tr) 0    (147*K+ 7*L-tr) 0
+ (147*K+ 7*L+tr) 0    (147*K+ 8*L-tr) 0
+ (147*K+ 8*L+tr) 0    (147*K+ 9*L-tr) 0
+ (147*K+ 9*L+tr) 0    (147*K+10*L-tr) 0
+ (147*K+10*L+tr) 0    (147*K+11*L-tr) 0
+ (147*K+11*L+tr) 0    (147*K+12*L-tr) 0
+ (147*K+12*L+tr) 0    (147*K+13*L-tr) 0
+ (147*K+13*L+tr) 0    (147*K+14*L-tr) 0
+ ]
vBitLine_2 (BitLine_2 0) vsource type=pwl wave=\[
+ ( 0*K   ) VDD  ( 1*K-tr) VDD
+ ( 1*K+tr) VDD  ( 2*K-tr) VDD
+ ( 2*K+tr) VDD  ( 3*K-tr) VDD
+ ( 3*K+tr) VDD  ( 4*K-tr) VDD
+ ( 4*K+tr) VDD  ( 5*K-tr) VDD
+ ( 5*K+tr) VDD  ( 6*K-tr) VDD
+ ( 6*K+tr) VDD  ( 7*K-tr) VDD
+ ( 7*K+tr) VDD  ( 8*K-tr) VDD
+ ( 8*K+tr) VDD  ( 9*K-tr) VDD
+ ( 9*K+tr) VDD  (10*K-tr) VDD
+ (10*K+tr) VDD  (11*K-tr) VDD
+ (11*K+tr) VDD  (12*K-tr) VDD
+ (12*K+tr) VDD  (13*K-tr) VDD
+ (13*K+tr) VDD  (14*K-tr) VDD
+ (14*K+tr) 0    (15*K-tr) 0
+ (15*K+tr) VDD  (16*K-tr) VDD
+ (16*K+tr) VDD  (17*K-tr) VDD
+ (17*K+tr) VDD  (18*K-tr) VDD
+ (18*K+tr) VDD  (19*K-tr) VDD
+ (19*K+tr) VDD  (20*K-tr) VDD
+ (20*K+tr) 0    (21*K-tr) 0
+ (21*K+tr) VDD  (22*K-tr) VDD
+ (22*K+tr) VDD  (23*K-tr) VDD
+ (23*K+tr) 0    (24*K-tr) 0
+ (24*K+tr) VDD  (25*K-tr) VDD
+ (25*K+tr) VDD  (26*K-tr) VDD
+ (26*K+tr) VDD  (27*K-tr) VDD
+ (27*K+tr) VDD  (28*K-tr) VDD
+ (28*K+tr) VDD  (29*K-tr) VDD
+ (29*K+tr) VDD  (30*K-tr) VDD
+ (30*K+tr) VDD  (31*K-tr) VDD
+ (31*K+tr) VDD  (32*K-tr) VDD
+ (32*K+tr) 0    (33*K-tr) 0
+ (33*K+tr) VDD  (34*K-tr) VDD
+ (34*K+tr) VDD  (35*K-tr) VDD
+ (35*K+tr) 0    (36*K-tr) 0
+ (36*K+tr) VDD  (37*K-tr) VDD
+ (37*K+tr) VDD  (38*K-tr) VDD
+ (38*K+tr) 0    (39*K-tr) 0
+ (39*K+tr) VDD  (40*K-tr) VDD
+ (40*K+tr) VDD  (41*K-tr) VDD
+ (41*K+tr) VDD  (42*K-tr) VDD
+ (42*K+tr) VDD  (43*K-tr) VDD
+ (43*K+tr) VDD  (44*K-tr) VDD
+ (44*K+tr) VDD  (45*K-tr) VDD
+ (45*K+tr) VDD  (46*K-tr) VDD
+ (46*K+tr) VDD  (47*K-tr) VDD
+ (47*K+tr) VDD  (48*K-tr) VDD
+ (48*K+tr) VDD  (49*K-tr) VDD
+ (49*K+tr) VDD  (50*K-tr) VDD
+ (50*K+tr) VDD  (51*K-tr) VDD
+ (51*K+tr) VDD  (52*K-tr) VDD
+ (52*K+tr) VDD  (53*K-tr) VDD
+ (53*K+tr) VDD  (54*K-tr) VDD
+ (54*K+tr) VDD  (55*K-tr) VDD
+ (55*K+tr) VDD  (56*K-tr) VDD
+ (56*K+tr) VDD  (57*K-tr) VDD
+ (57*K+tr) VDD  (58*K-tr) VDD
+ (58*K+tr) VDD  (59*K-tr) VDD
+ (59*K+tr) VDD  (60*K-tr) VDD
+ (60*K+tr) VDD  (61*K-tr) VDD
+ (61*K+tr) VDD  (62*K-tr) VDD
+ (62*K+tr) VDD  (63*K-tr) VDD
+ (63*K+tr) VDD  (64*K-tr) VDD
+ (64*K+tr) VDD  (65*K-tr) VDD
+ (65*K+tr) VDD  (66*K-tr) VDD
+ (66*K+tr) VDD  (67*K-tr) VDD
+ (67*K+tr) VDD  (68*K-tr) VDD
+ (68*K+tr) VDD  (69*K-tr) VDD
+ (69*K+tr) VDD  (70*K-tr) VDD
+ (70*K+tr) VDD  (71*K-tr) VDD
+ (71*K+tr) VDD  (72*K-tr) VDD
+ (72*K+tr) VDD  (73*K-tr) VDD
+ (73*K+tr) VDD  (74*K-tr) VDD
+ (74*K+tr) VDD  (75*K-tr) VDD
+ (75*K+tr) 0    (76*K-tr) 0
+ (76*K+tr) VDD  (77*K-tr) VDD
+ (77*K+tr) 0    (78*K-tr) 0
+ (78*K+tr) VDD  (79*K-tr) VDD
+ (79*K+tr) VDD  (80*K-tr) VDD
+ (80*K+tr) VDD  (81*K-tr) VDD
+ (81*K+tr) VDD  (82*K-tr) VDD
+ (82*K+tr) VDD  (83*K-tr) VDD
+ (83*K+tr) VDD  (84*K-tr) VDD
+ (84*K+tr) 0    (85*K-tr) 0
+ (85*K+tr) VDD  (86*K-tr) VDD
+ (86*K+tr) 0    (87*K-tr) 0
+ (87*K+tr) VDD  (88*K-tr) VDD
+ (88*K+tr) VDD  (89*K-tr) VDD
+ (89*K+tr) VDD  (90*K-tr) VDD
+ (90*K+tr) VDD  (91*K-tr) VDD
+ (91*K+tr) VDD  (92*K-tr) VDD
+ (92*K+tr) VDD  (93*K-tr) VDD
+ (93*K+tr) 0    (94*K-tr) 0
+ (94*K+tr) VDD  (95*K-tr) VDD
+ (95*K+tr) 0    (96*K-tr) 0
+ (96*K+tr) VDD  (97*K-tr) VDD
+ (97*K+tr) VDD  (98*K-tr) VDD
+ (98*K+tr) VDD  (99*K-tr) VDD
+ (99*K+tr) VDD  (100*K-tr) VDD
+ (100*K+tr) VDD  (101*K-tr) VDD
+ (101*K+tr) VDD  (102*K-tr) VDD
+ (102*K+tr) VDD  (103*K-tr) VDD
+ (103*K+tr) VDD  (104*K-tr) VDD
+ (104*K+tr) VDD  (105*K-tr) VDD
+ (105*K+tr) VDD  (106*K-tr) VDD
+ (106*K+tr) 0    (107*K-tr) 0
+ (107*K+tr) VDD  (108*K-tr) VDD
+ (108*K+tr) VDD  (109*K-tr) VDD
+ (109*K+tr) 0    (110*K-tr) 0
+ (110*K+tr) VDD  (111*K-tr) VDD
+ (111*K+tr) VDD  (112*K-tr) VDD
+ (112*K+tr) VDD  (113*K-tr) VDD
+ (113*K+tr) VDD  (114*K-tr) VDD
+ (114*K+tr) VDD  (115*K-tr) VDD
+ (115*K+tr) 0    (116*K-tr) 0
+ (116*K+tr) VDD  (117*K-tr) VDD
+ (117*K+tr) VDD  (118*K-tr) VDD
+ (118*K+tr) 0    (119*K-tr) 0
+ (119*K+tr) VDD  (120*K-tr) VDD
+ (120*K+tr) VDD  (121*K-tr) VDD
+ (121*K+tr) VDD  (122*K-tr) VDD
+ (122*K+tr) VDD  (123*K-tr) VDD
+ (123*K+tr) VDD  (124*K-tr) VDD
+ (124*K+tr) 0    (125*K-tr) 0
+ (125*K+tr) VDD  (126*K-tr) VDD
+ (126*K+tr) VDD  (127*K-tr) VDD
+ (127*K+tr) 0    (128*K-tr) 0
+ (128*K+tr) VDD  (129*K-tr) VDD
+ (129*K+tr) VDD  (130*K-tr) VDD
+ (130*K+tr) VDD  (131*K-tr) VDD
+ (131*K+tr) VDD  (132*K-tr) VDD
+ (132*K+tr) VDD  (133*K-tr) VDD
+ (133*K+tr) 0    (134*K-tr) 0
+ (134*K+tr) VDD  (135*K-tr) VDD
+ (135*K+tr) VDD  (136*K-tr) VDD
+ (136*K+tr) 0    (137*K-tr) 0
+ (137*K+tr) VDD  (138*K-tr) VDD
+ (138*K+tr) VDD  (139*K-tr) VDD
+ (139*K+tr) VDD  (140*K-tr) VDD
+ (140*K+tr) VDD  (141*K-tr) VDD
+ (141*K+tr) VDD  (142*K-tr) VDD
+ (142*K+tr) VDD  (143*K-tr) VDD
+ (143*K+tr) VDD  (144*K-tr) VDD
+ (144*K+tr) VDD  (145*K-tr) VDD
+ (145*K+tr) VDD  (146*K-tr) VDD
+ (146*K+tr) VDD  (147*K-tr) VDD
+ (147*K+ 0*L+tr) VDD  (147*K+ 1*L-tr) VDD
+ (147*K+ 1*L+tr) VDD  (147*K+ 2*L-tr) VDD
+ (147*K+ 2*L+tr) VDD  (147*K+ 3*L-tr) VDD
+ (147*K+ 3*L+tr) VDD  (147*K+ 4*L-tr) VDD
+ (147*K+ 4*L+tr) VDD  (147*K+ 5*L-tr) VDD
+ (147*K+ 5*L+tr) VDD  (147*K+ 6*L-tr) VDD
+ (147*K+ 6*L+tr) VDD  (147*K+ 7*L-tr) VDD
+ (147*K+ 7*L+tr) VDD  (147*K+ 8*L-tr) VDD
+ (147*K+ 8*L+tr) VDD  (147*K+ 9*L-tr) VDD
+ (147*K+ 9*L+tr) VDD  (147*K+10*L-tr) VDD
+ (147*K+10*L+tr) VDD  (147*K+11*L-tr) VDD
+ (147*K+11*L+tr) VDD  (147*K+12*L-tr) VDD
+ (147*K+12*L+tr) VDD  (147*K+13*L-tr) VDD
+ (147*K+13*L+tr) VDD  (147*K+14*L-tr) VDD
+ ]
vBitLine3 (BitLine3 0) vsource type=pwl wave=\[
+ ( 0*K   ) 0    ( 1*K-tr) 0
+ ( 1*K+tr) 0    ( 2*K-tr) 0
+ ( 2*K+tr) 0    ( 3*K-tr) 0
+ ( 3*K+tr) 0    ( 4*K-tr) 0
+ ( 4*K+tr) 0    ( 5*K-tr) 0
+ ( 5*K+tr) VDD  ( 6*K-tr) VDD
+ ( 6*K+tr) 0    ( 7*K-tr) 0
+ ( 7*K+tr) 0    ( 8*K-tr) 0
+ ( 8*K+tr) VDD  ( 9*K-tr) VDD
+ ( 9*K+tr) 0    (10*K-tr) 0
+ (10*K+tr) 0    (11*K-tr) 0
+ (11*K+tr) VDD  (12*K-tr) VDD
+ (12*K+tr) 0    (13*K-tr) 0
+ (13*K+tr) 0    (14*K-tr) 0
+ (14*K+tr) 0    (15*K-tr) 0
+ (15*K+tr) 0    (16*K-tr) 0
+ (16*K+tr) 0    (17*K-tr) 0
+ (17*K+tr) 0    (18*K-tr) 0
+ (18*K+tr) 0    (19*K-tr) 0
+ (19*K+tr) 0    (20*K-tr) 0
+ (20*K+tr) 0    (21*K-tr) 0
+ (21*K+tr) 0    (22*K-tr) 0
+ (22*K+tr) 0    (23*K-tr) 0
+ (23*K+tr) VDD  (24*K-tr) VDD
+ (24*K+tr) 0    (25*K-tr) 0
+ (25*K+tr) 0    (26*K-tr) 0
+ (26*K+tr) 0    (27*K-tr) 0
+ (27*K+tr) 0    (28*K-tr) 0
+ (28*K+tr) 0    (29*K-tr) 0
+ (29*K+tr) VDD  (30*K-tr) VDD
+ (30*K+tr) 0    (31*K-tr) 0
+ (31*K+tr) 0    (32*K-tr) 0
+ (32*K+tr) 0    (33*K-tr) 0
+ (33*K+tr) 0    (34*K-tr) 0
+ (34*K+tr) 0    (35*K-tr) 0
+ (35*K+tr) 0    (36*K-tr) 0
+ (36*K+tr) 0    (37*K-tr) 0
+ (37*K+tr) 0    (38*K-tr) 0
+ (38*K+tr) 0    (39*K-tr) 0
+ (39*K+tr) 0    (40*K-tr) 0
+ (40*K+tr) 0    (41*K-tr) 0
+ (41*K+tr) 0    (42*K-tr) 0
+ (42*K+tr) 0    (43*K-tr) 0
+ (43*K+tr) 0    (44*K-tr) 0
+ (44*K+tr) 0    (45*K-tr) 0
+ (45*K+tr) 0    (46*K-tr) 0
+ (46*K+tr) 0    (47*K-tr) 0
+ (47*K+tr) 0    (48*K-tr) 0
+ (48*K+tr) 0    (49*K-tr) 0
+ (49*K+tr) 0    (50*K-tr) 0
+ (50*K+tr) 0    (51*K-tr) 0
+ (51*K+tr) 0    (52*K-tr) 0
+ (52*K+tr) 0    (53*K-tr) 0
+ (53*K+tr) 0    (54*K-tr) 0
+ (54*K+tr) 0    (55*K-tr) 0
+ (55*K+tr) 0    (56*K-tr) 0
+ (56*K+tr) 0    (57*K-tr) 0
+ (57*K+tr) 0    (58*K-tr) 0
+ (58*K+tr) 0    (59*K-tr) 0
+ (59*K+tr) 0    (60*K-tr) 0
+ (60*K+tr) 0    (61*K-tr) 0
+ (61*K+tr) 0    (62*K-tr) 0
+ (62*K+tr) 0    (63*K-tr) 0
+ (63*K+tr) 0    (64*K-tr) 0
+ (64*K+tr) 0    (65*K-tr) 0
+ (65*K+tr) 0    (66*K-tr) 0
+ (66*K+tr) VDD  (67*K-tr) VDD
+ (67*K+tr) 0    (68*K-tr) 0
+ (68*K+tr) 0    (69*K-tr) 0
+ (69*K+tr) 0    (70*K-tr) 0
+ (70*K+tr) 0    (71*K-tr) 0
+ (71*K+tr) 0    (72*K-tr) 0
+ (72*K+tr) 0    (73*K-tr) 0
+ (73*K+tr) 0    (74*K-tr) 0
+ (74*K+tr) 0    (75*K-tr) 0
+ (75*K+tr) 0    (76*K-tr) 0
+ (76*K+tr) 0    (77*K-tr) 0
+ (77*K+tr) VDD  (78*K-tr) VDD
+ (78*K+tr) 0    (79*K-tr) 0
+ (79*K+tr) 0    (80*K-tr) 0
+ (80*K+tr) 0    (81*K-tr) 0
+ (81*K+tr) 0    (82*K-tr) 0
+ (82*K+tr) 0    (83*K-tr) 0
+ (83*K+tr) 0    (84*K-tr) 0
+ (84*K+tr) VDD  (85*K-tr) VDD
+ (85*K+tr) 0    (86*K-tr) 0
+ (86*K+tr) VDD  (87*K-tr) VDD
+ (87*K+tr) 0    (88*K-tr) 0
+ (88*K+tr) 0    (89*K-tr) 0
+ (89*K+tr) 0    (90*K-tr) 0
+ (90*K+tr) 0    (91*K-tr) 0
+ (91*K+tr) 0    (92*K-tr) 0
+ (92*K+tr) 0    (93*K-tr) 0
+ (93*K+tr) 0    (94*K-tr) 0
+ (94*K+tr) 0    (95*K-tr) 0
+ (95*K+tr) VDD  (96*K-tr) VDD
+ (96*K+tr) 0    (97*K-tr) 0
+ (97*K+tr) 0    (98*K-tr) 0
+ (98*K+tr) 0    (99*K-tr) 0
+ (99*K+tr) VDD  (100*K-tr) VDD
+ (100*K+tr) 0    (101*K-tr) 0
+ (101*K+tr) 0    (102*K-tr) 0
+ (102*K+tr) 0    (103*K-tr) 0
+ (103*K+tr) 0    (104*K-tr) 0
+ (104*K+tr) 0    (105*K-tr) 0
+ (105*K+tr) 0    (106*K-tr) 0
+ (106*K+tr) VDD  (107*K-tr) VDD
+ (107*K+tr) 0    (108*K-tr) 0
+ (108*K+tr) 0    (109*K-tr) 0
+ (109*K+tr) VDD  (110*K-tr) VDD
+ (110*K+tr) 0    (111*K-tr) 0
+ (111*K+tr) 0    (112*K-tr) 0
+ (112*K+tr) 0    (113*K-tr) 0
+ (113*K+tr) 0    (114*K-tr) 0
+ (114*K+tr) 0    (115*K-tr) 0
+ (115*K+tr) VDD  (116*K-tr) VDD
+ (116*K+tr) 0    (117*K-tr) 0
+ (117*K+tr) 0    (118*K-tr) 0
+ (118*K+tr) VDD  (119*K-tr) VDD
+ (119*K+tr) 0    (120*K-tr) 0
+ (120*K+tr) 0    (121*K-tr) 0
+ (121*K+tr) 0    (122*K-tr) 0
+ (122*K+tr) 0    (123*K-tr) 0
+ (123*K+tr) 0    (124*K-tr) 0
+ (124*K+tr) VDD  (125*K-tr) VDD
+ (125*K+tr) 0    (126*K-tr) 0
+ (126*K+tr) 0    (127*K-tr) 0
+ (127*K+tr) VDD  (128*K-tr) VDD
+ (128*K+tr) 0    (129*K-tr) 0
+ (129*K+tr) 0    (130*K-tr) 0
+ (130*K+tr) 0    (131*K-tr) 0
+ (131*K+tr) 0    (132*K-tr) 0
+ (132*K+tr) 0    (133*K-tr) 0
+ (133*K+tr) VDD  (134*K-tr) VDD
+ (134*K+tr) 0    (135*K-tr) 0
+ (135*K+tr) 0    (136*K-tr) 0
+ (136*K+tr) VDD  (137*K-tr) VDD
+ (137*K+tr) 0    (138*K-tr) 0
+ (138*K+tr) VDD  (139*K-tr) VDD
+ (139*K+tr) 0    (140*K-tr) 0
+ (140*K+tr) 0    (141*K-tr) 0
+ (141*K+tr) 0    (142*K-tr) 0
+ (142*K+tr) 0    (143*K-tr) 0
+ (143*K+tr) 0    (144*K-tr) 0
+ (144*K+tr) 0    (145*K-tr) 0
+ (145*K+tr) 0    (146*K-tr) 0
+ (146*K+tr) 0    (147*K-tr) 0
+ (147*K+ 0*L+tr) 0    (147*K+ 1*L-tr) 0
+ (147*K+ 1*L+tr) 0    (147*K+ 2*L-tr) 0
+ (147*K+ 2*L+tr) 0    (147*K+ 3*L-tr) 0
+ (147*K+ 3*L+tr) 0    (147*K+ 4*L-tr) 0
+ (147*K+ 4*L+tr) 0    (147*K+ 5*L-tr) 0
+ (147*K+ 5*L+tr) 0    (147*K+ 6*L-tr) 0
+ (147*K+ 6*L+tr) 0    (147*K+ 7*L-tr) 0
+ (147*K+ 7*L+tr) 0    (147*K+ 8*L-tr) 0
+ (147*K+ 8*L+tr) 0    (147*K+ 9*L-tr) 0
+ (147*K+ 9*L+tr) 0    (147*K+10*L-tr) 0
+ (147*K+10*L+tr) 0    (147*K+11*L-tr) 0
+ (147*K+11*L+tr) 0    (147*K+12*L-tr) 0
+ (147*K+12*L+tr) 0    (147*K+13*L-tr) 0
+ (147*K+13*L+tr) 0    (147*K+14*L-tr) 0
+ ]
vBitLine_3 (BitLine_3 0) vsource type=pwl wave=\[
+ ( 0*K   ) VDD  ( 1*K-tr) VDD
+ ( 1*K+tr) VDD  ( 2*K-tr) VDD
+ ( 2*K+tr) VDD  ( 3*K-tr) VDD
+ ( 3*K+tr) VDD  ( 4*K-tr) VDD
+ ( 4*K+tr) VDD  ( 5*K-tr) VDD
+ ( 5*K+tr) 0    ( 6*K-tr) 0
+ ( 6*K+tr) VDD  ( 7*K-tr) VDD
+ ( 7*K+tr) VDD  ( 8*K-tr) VDD
+ ( 8*K+tr) 0    ( 9*K-tr) 0
+ ( 9*K+tr) VDD  (10*K-tr) VDD
+ (10*K+tr) VDD  (11*K-tr) VDD
+ (11*K+tr) 0    (12*K-tr) 0
+ (12*K+tr) VDD  (13*K-tr) VDD
+ (13*K+tr) VDD  (14*K-tr) VDD
+ (14*K+tr) VDD  (15*K-tr) VDD
+ (15*K+tr) VDD  (16*K-tr) VDD
+ (16*K+tr) VDD  (17*K-tr) VDD
+ (17*K+tr) VDD  (18*K-tr) VDD
+ (18*K+tr) VDD  (19*K-tr) VDD
+ (19*K+tr) VDD  (20*K-tr) VDD
+ (20*K+tr) VDD  (21*K-tr) VDD
+ (21*K+tr) VDD  (22*K-tr) VDD
+ (22*K+tr) VDD  (23*K-tr) VDD
+ (23*K+tr) 0    (24*K-tr) 0
+ (24*K+tr) VDD  (25*K-tr) VDD
+ (25*K+tr) VDD  (26*K-tr) VDD
+ (26*K+tr) VDD  (27*K-tr) VDD
+ (27*K+tr) VDD  (28*K-tr) VDD
+ (28*K+tr) VDD  (29*K-tr) VDD
+ (29*K+tr) 0    (30*K-tr) 0
+ (30*K+tr) VDD  (31*K-tr) VDD
+ (31*K+tr) VDD  (32*K-tr) VDD
+ (32*K+tr) VDD  (33*K-tr) VDD
+ (33*K+tr) VDD  (34*K-tr) VDD
+ (34*K+tr) VDD  (35*K-tr) VDD
+ (35*K+tr) VDD  (36*K-tr) VDD
+ (36*K+tr) VDD  (37*K-tr) VDD
+ (37*K+tr) VDD  (38*K-tr) VDD
+ (38*K+tr) VDD  (39*K-tr) VDD
+ (39*K+tr) VDD  (40*K-tr) VDD
+ (40*K+tr) VDD  (41*K-tr) VDD
+ (41*K+tr) VDD  (42*K-tr) VDD
+ (42*K+tr) VDD  (43*K-tr) VDD
+ (43*K+tr) VDD  (44*K-tr) VDD
+ (44*K+tr) VDD  (45*K-tr) VDD
+ (45*K+tr) VDD  (46*K-tr) VDD
+ (46*K+tr) VDD  (47*K-tr) VDD
+ (47*K+tr) VDD  (48*K-tr) VDD
+ (48*K+tr) VDD  (49*K-tr) VDD
+ (49*K+tr) VDD  (50*K-tr) VDD
+ (50*K+tr) VDD  (51*K-tr) VDD
+ (51*K+tr) VDD  (52*K-tr) VDD
+ (52*K+tr) VDD  (53*K-tr) VDD
+ (53*K+tr) VDD  (54*K-tr) VDD
+ (54*K+tr) VDD  (55*K-tr) VDD
+ (55*K+tr) VDD  (56*K-tr) VDD
+ (56*K+tr) VDD  (57*K-tr) VDD
+ (57*K+tr) VDD  (58*K-tr) VDD
+ (58*K+tr) VDD  (59*K-tr) VDD
+ (59*K+tr) VDD  (60*K-tr) VDD
+ (60*K+tr) VDD  (61*K-tr) VDD
+ (61*K+tr) VDD  (62*K-tr) VDD
+ (62*K+tr) VDD  (63*K-tr) VDD
+ (63*K+tr) VDD  (64*K-tr) VDD
+ (64*K+tr) VDD  (65*K-tr) VDD
+ (65*K+tr) VDD  (66*K-tr) VDD
+ (66*K+tr) 0    (67*K-tr) 0
+ (67*K+tr) VDD  (68*K-tr) VDD
+ (68*K+tr) VDD  (69*K-tr) VDD
+ (69*K+tr) VDD  (70*K-tr) VDD
+ (70*K+tr) VDD  (71*K-tr) VDD
+ (71*K+tr) VDD  (72*K-tr) VDD
+ (72*K+tr) VDD  (73*K-tr) VDD
+ (73*K+tr) VDD  (74*K-tr) VDD
+ (74*K+tr) VDD  (75*K-tr) VDD
+ (75*K+tr) VDD  (76*K-tr) VDD
+ (76*K+tr) VDD  (77*K-tr) VDD
+ (77*K+tr) 0    (78*K-tr) 0
+ (78*K+tr) VDD  (79*K-tr) VDD
+ (79*K+tr) VDD  (80*K-tr) VDD
+ (80*K+tr) VDD  (81*K-tr) VDD
+ (81*K+tr) VDD  (82*K-tr) VDD
+ (82*K+tr) VDD  (83*K-tr) VDD
+ (83*K+tr) VDD  (84*K-tr) VDD
+ (84*K+tr) 0    (85*K-tr) 0
+ (85*K+tr) VDD  (86*K-tr) VDD
+ (86*K+tr) 0    (87*K-tr) 0
+ (87*K+tr) VDD  (88*K-tr) VDD
+ (88*K+tr) VDD  (89*K-tr) VDD
+ (89*K+tr) VDD  (90*K-tr) VDD
+ (90*K+tr) VDD  (91*K-tr) VDD
+ (91*K+tr) VDD  (92*K-tr) VDD
+ (92*K+tr) VDD  (93*K-tr) VDD
+ (93*K+tr) VDD  (94*K-tr) VDD
+ (94*K+tr) VDD  (95*K-tr) VDD
+ (95*K+tr) 0    (96*K-tr) 0
+ (96*K+tr) VDD  (97*K-tr) VDD
+ (97*K+tr) VDD  (98*K-tr) VDD
+ (98*K+tr) VDD  (99*K-tr) VDD
+ (99*K+tr) 0    (100*K-tr) 0
+ (100*K+tr) VDD  (101*K-tr) VDD
+ (101*K+tr) VDD  (102*K-tr) VDD
+ (102*K+tr) VDD  (103*K-tr) VDD
+ (103*K+tr) VDD  (104*K-tr) VDD
+ (104*K+tr) VDD  (105*K-tr) VDD
+ (105*K+tr) VDD  (106*K-tr) VDD
+ (106*K+tr) 0    (107*K-tr) 0
+ (107*K+tr) VDD  (108*K-tr) VDD
+ (108*K+tr) VDD  (109*K-tr) VDD
+ (109*K+tr) 0    (110*K-tr) 0
+ (110*K+tr) VDD  (111*K-tr) VDD
+ (111*K+tr) VDD  (112*K-tr) VDD
+ (112*K+tr) VDD  (113*K-tr) VDD
+ (113*K+tr) VDD  (114*K-tr) VDD
+ (114*K+tr) VDD  (115*K-tr) VDD
+ (115*K+tr) 0    (116*K-tr) 0
+ (116*K+tr) VDD  (117*K-tr) VDD
+ (117*K+tr) VDD  (118*K-tr) VDD
+ (118*K+tr) 0    (119*K-tr) 0
+ (119*K+tr) VDD  (120*K-tr) VDD
+ (120*K+tr) VDD  (121*K-tr) VDD
+ (121*K+tr) VDD  (122*K-tr) VDD
+ (122*K+tr) VDD  (123*K-tr) VDD
+ (123*K+tr) VDD  (124*K-tr) VDD
+ (124*K+tr) 0    (125*K-tr) 0
+ (125*K+tr) VDD  (126*K-tr) VDD
+ (126*K+tr) VDD  (127*K-tr) VDD
+ (127*K+tr) 0    (128*K-tr) 0
+ (128*K+tr) VDD  (129*K-tr) VDD
+ (129*K+tr) VDD  (130*K-tr) VDD
+ (130*K+tr) VDD  (131*K-tr) VDD
+ (131*K+tr) VDD  (132*K-tr) VDD
+ (132*K+tr) VDD  (133*K-tr) VDD
+ (133*K+tr) 0    (134*K-tr) 0
+ (134*K+tr) VDD  (135*K-tr) VDD
+ (135*K+tr) VDD  (136*K-tr) VDD
+ (136*K+tr) 0    (137*K-tr) 0
+ (137*K+tr) VDD  (138*K-tr) VDD
+ (138*K+tr) 0    (139*K-tr) 0
+ (139*K+tr) VDD  (140*K-tr) VDD
+ (140*K+tr) VDD  (141*K-tr) VDD
+ (141*K+tr) VDD  (142*K-tr) VDD
+ (142*K+tr) VDD  (143*K-tr) VDD
+ (143*K+tr) VDD  (144*K-tr) VDD
+ (144*K+tr) VDD  (145*K-tr) VDD
+ (145*K+tr) VDD  (146*K-tr) VDD
+ (146*K+tr) VDD  (147*K-tr) VDD
+ (147*K+ 0*L+tr) VDD  (147*K+ 1*L-tr) VDD
+ (147*K+ 1*L+tr) VDD  (147*K+ 2*L-tr) VDD
+ (147*K+ 2*L+tr) VDD  (147*K+ 3*L-tr) VDD
+ (147*K+ 3*L+tr) VDD  (147*K+ 4*L-tr) VDD
+ (147*K+ 4*L+tr) VDD  (147*K+ 5*L-tr) VDD
+ (147*K+ 5*L+tr) VDD  (147*K+ 6*L-tr) VDD
+ (147*K+ 6*L+tr) VDD  (147*K+ 7*L-tr) VDD
+ (147*K+ 7*L+tr) VDD  (147*K+ 8*L-tr) VDD
+ (147*K+ 8*L+tr) VDD  (147*K+ 9*L-tr) VDD
+ (147*K+ 9*L+tr) VDD  (147*K+10*L-tr) VDD
+ (147*K+10*L+tr) VDD  (147*K+11*L-tr) VDD
+ (147*K+11*L+tr) VDD  (147*K+12*L-tr) VDD
+ (147*K+12*L+tr) VDD  (147*K+13*L-tr) VDD
+ (147*K+13*L+tr) VDD  (147*K+14*L-tr) VDD
+ ]
vBitLine4 (BitLine4 0) vsource type=pwl wave=\[
+ ( 0*K   ) 0    ( 1*K-tr) 0
+ ( 1*K+tr) 0    ( 2*K-tr) 0
+ ( 2*K+tr) 0    ( 3*K-tr) 0
+ ( 3*K+tr) 0    ( 4*K-tr) 0
+ ( 4*K+tr) 0    ( 5*K-tr) 0
+ ( 5*K+tr) 0    ( 6*K-tr) 0
+ ( 6*K+tr) 0    ( 7*K-tr) 0
+ ( 7*K+tr) 0    ( 8*K-tr) 0
+ ( 8*K+tr) VDD  ( 9*K-tr) VDD
+ ( 9*K+tr) 0    (10*K-tr) 0
+ (10*K+tr) 0    (11*K-tr) 0
+ (11*K+tr) 0    (12*K-tr) 0
+ (12*K+tr) 0    (13*K-tr) 0
+ (13*K+tr) 0    (14*K-tr) 0
+ (14*K+tr) 0    (15*K-tr) 0
+ (15*K+tr) 0    (16*K-tr) 0
+ (16*K+tr) 0    (17*K-tr) 0
+ (17*K+tr) 0    (18*K-tr) 0
+ (18*K+tr) 0    (19*K-tr) 0
+ (19*K+tr) 0    (20*K-tr) 0
+ (20*K+tr) 0    (21*K-tr) 0
+ (21*K+tr) 0    (22*K-tr) 0
+ (22*K+tr) 0    (23*K-tr) 0
+ (23*K+tr) 0    (24*K-tr) 0
+ (24*K+tr) 0    (25*K-tr) 0
+ (25*K+tr) 0    (26*K-tr) 0
+ (26*K+tr) 0    (27*K-tr) 0
+ (27*K+tr) 0    (28*K-tr) 0
+ (28*K+tr) 0    (29*K-tr) 0
+ (29*K+tr) 0    (30*K-tr) 0
+ (30*K+tr) 0    (31*K-tr) 0
+ (31*K+tr) 0    (32*K-tr) 0
+ (32*K+tr) 0    (33*K-tr) 0
+ (33*K+tr) 0    (34*K-tr) 0
+ (34*K+tr) 0    (35*K-tr) 0
+ (35*K+tr) 0    (36*K-tr) 0
+ (36*K+tr) 0    (37*K-tr) 0
+ (37*K+tr) 0    (38*K-tr) 0
+ (38*K+tr) 0    (39*K-tr) 0
+ (39*K+tr) 0    (40*K-tr) 0
+ (40*K+tr) 0    (41*K-tr) 0
+ (41*K+tr) 0    (42*K-tr) 0
+ (42*K+tr) 0    (43*K-tr) 0
+ (43*K+tr) 0    (44*K-tr) 0
+ (44*K+tr) 0    (45*K-tr) 0
+ (45*K+tr) 0    (46*K-tr) 0
+ (46*K+tr) 0    (47*K-tr) 0
+ (47*K+tr) 0    (48*K-tr) 0
+ (48*K+tr) 0    (49*K-tr) 0
+ (49*K+tr) 0    (50*K-tr) 0
+ (50*K+tr) 0    (51*K-tr) 0
+ (51*K+tr) 0    (52*K-tr) 0
+ (52*K+tr) VDD  (53*K-tr) VDD
+ (53*K+tr) 0    (54*K-tr) 0
+ (54*K+tr) 0    (55*K-tr) 0
+ (55*K+tr) 0    (56*K-tr) 0
+ (56*K+tr) 0    (57*K-tr) 0
+ (57*K+tr) 0    (58*K-tr) 0
+ (58*K+tr) 0    (59*K-tr) 0
+ (59*K+tr) 0    (60*K-tr) 0
+ (60*K+tr) 0    (61*K-tr) 0
+ (61*K+tr) VDD  (62*K-tr) VDD
+ (62*K+tr) 0    (63*K-tr) 0
+ (63*K+tr) 0    (64*K-tr) 0
+ (64*K+tr) 0    (65*K-tr) 0
+ (65*K+tr) 0    (66*K-tr) 0
+ (66*K+tr) 0    (67*K-tr) 0
+ (67*K+tr) 0    (68*K-tr) 0
+ (68*K+tr) 0    (69*K-tr) 0
+ (69*K+tr) 0    (70*K-tr) 0
+ (70*K+tr) 0    (71*K-tr) 0
+ (71*K+tr) 0    (72*K-tr) 0
+ (72*K+tr) 0    (73*K-tr) 0
+ (73*K+tr) 0    (74*K-tr) 0
+ (74*K+tr) 0    (75*K-tr) 0
+ (75*K+tr) 0    (76*K-tr) 0
+ (76*K+tr) 0    (77*K-tr) 0
+ (77*K+tr) VDD  (78*K-tr) VDD
+ (78*K+tr) 0    (79*K-tr) 0
+ (79*K+tr) 0    (80*K-tr) 0
+ (80*K+tr) 0    (81*K-tr) 0
+ (81*K+tr) 0    (82*K-tr) 0
+ (82*K+tr) 0    (83*K-tr) 0
+ (83*K+tr) 0    (84*K-tr) 0
+ (84*K+tr) 0    (85*K-tr) 0
+ (85*K+tr) 0    (86*K-tr) 0
+ (86*K+tr) VDD  (87*K-tr) VDD
+ (87*K+tr) 0    (88*K-tr) 0
+ (88*K+tr) 0    (89*K-tr) 0
+ (89*K+tr) 0    (90*K-tr) 0
+ (90*K+tr) 0    (91*K-tr) 0
+ (91*K+tr) 0    (92*K-tr) 0
+ (92*K+tr) 0    (93*K-tr) 0
+ (93*K+tr) 0    (94*K-tr) 0
+ (94*K+tr) 0    (95*K-tr) 0
+ (95*K+tr) VDD  (96*K-tr) VDD
+ (96*K+tr) 0    (97*K-tr) 0
+ (97*K+tr) 0    (98*K-tr) 0
+ (98*K+tr) 0    (99*K-tr) 0
+ (99*K+tr) 0    (100*K-tr) 0
+ (100*K+tr) 0    (101*K-tr) 0
+ (101*K+tr) 0    (102*K-tr) 0
+ (102*K+tr) 0    (103*K-tr) 0
+ (103*K+tr) 0    (104*K-tr) 0
+ (104*K+tr) 0    (105*K-tr) 0
+ (105*K+tr) 0    (106*K-tr) 0
+ (106*K+tr) VDD  (107*K-tr) VDD
+ (107*K+tr) 0    (108*K-tr) 0
+ (108*K+tr) 0    (109*K-tr) 0
+ (109*K+tr) VDD  (110*K-tr) VDD
+ (110*K+tr) 0    (111*K-tr) 0
+ (111*K+tr) 0    (112*K-tr) 0
+ (112*K+tr) 0    (113*K-tr) 0
+ (113*K+tr) 0    (114*K-tr) 0
+ (114*K+tr) 0    (115*K-tr) 0
+ (115*K+tr) VDD  (116*K-tr) VDD
+ (116*K+tr) 0    (117*K-tr) 0
+ (117*K+tr) 0    (118*K-tr) 0
+ (118*K+tr) VDD  (119*K-tr) VDD
+ (119*K+tr) 0    (120*K-tr) 0
+ (120*K+tr) 0    (121*K-tr) 0
+ (121*K+tr) 0    (122*K-tr) 0
+ (122*K+tr) 0    (123*K-tr) 0
+ (123*K+tr) 0    (124*K-tr) 0
+ (124*K+tr) VDD  (125*K-tr) VDD
+ (125*K+tr) 0    (126*K-tr) 0
+ (126*K+tr) 0    (127*K-tr) 0
+ (127*K+tr) VDD  (128*K-tr) VDD
+ (128*K+tr) 0    (129*K-tr) 0
+ (129*K+tr) 0    (130*K-tr) 0
+ (130*K+tr) 0    (131*K-tr) 0
+ (131*K+tr) 0    (132*K-tr) 0
+ (132*K+tr) 0    (133*K-tr) 0
+ (133*K+tr) VDD  (134*K-tr) VDD
+ (134*K+tr) 0    (135*K-tr) 0
+ (135*K+tr) 0    (136*K-tr) 0
+ (136*K+tr) VDD  (137*K-tr) VDD
+ (137*K+tr) 0    (138*K-tr) 0
+ (138*K+tr) 0    (139*K-tr) 0
+ (139*K+tr) 0    (140*K-tr) 0
+ (140*K+tr) 0    (141*K-tr) 0
+ (141*K+tr) 0    (142*K-tr) 0
+ (142*K+tr) 0    (143*K-tr) 0
+ (143*K+tr) 0    (144*K-tr) 0
+ (144*K+tr) 0    (145*K-tr) 0
+ (145*K+tr) 0    (146*K-tr) 0
+ (146*K+tr) 0    (147*K-tr) 0
+ (147*K+ 0*L+tr) 0    (147*K+ 1*L-tr) 0
+ (147*K+ 1*L+tr) 0    (147*K+ 2*L-tr) 0
+ (147*K+ 2*L+tr) 0    (147*K+ 3*L-tr) 0
+ (147*K+ 3*L+tr) 0    (147*K+ 4*L-tr) 0
+ (147*K+ 4*L+tr) 0    (147*K+ 5*L-tr) 0
+ (147*K+ 5*L+tr) 0    (147*K+ 6*L-tr) 0
+ (147*K+ 6*L+tr) 0    (147*K+ 7*L-tr) 0
+ (147*K+ 7*L+tr) 0    (147*K+ 8*L-tr) 0
+ (147*K+ 8*L+tr) 0    (147*K+ 9*L-tr) 0
+ (147*K+ 9*L+tr) 0    (147*K+10*L-tr) 0
+ (147*K+10*L+tr) 0    (147*K+11*L-tr) 0
+ (147*K+11*L+tr) 0    (147*K+12*L-tr) 0
+ (147*K+12*L+tr) 0    (147*K+13*L-tr) 0
+ (147*K+13*L+tr) 0    (147*K+14*L-tr) 0
+ ]
vBitLine_4 (BitLine_4 0) vsource type=pwl wave=\[
+ ( 0*K   ) VDD  ( 1*K-tr) VDD
+ ( 1*K+tr) VDD  ( 2*K-tr) VDD
+ ( 2*K+tr) VDD  ( 3*K-tr) VDD
+ ( 3*K+tr) VDD  ( 4*K-tr) VDD
+ ( 4*K+tr) VDD  ( 5*K-tr) VDD
+ ( 5*K+tr) VDD  ( 6*K-tr) VDD
+ ( 6*K+tr) VDD  ( 7*K-tr) VDD
+ ( 7*K+tr) VDD  ( 8*K-tr) VDD
+ ( 8*K+tr) 0    ( 9*K-tr) 0
+ ( 9*K+tr) VDD  (10*K-tr) VDD
+ (10*K+tr) VDD  (11*K-tr) VDD
+ (11*K+tr) VDD  (12*K-tr) VDD
+ (12*K+tr) VDD  (13*K-tr) VDD
+ (13*K+tr) VDD  (14*K-tr) VDD
+ (14*K+tr) VDD  (15*K-tr) VDD
+ (15*K+tr) VDD  (16*K-tr) VDD
+ (16*K+tr) VDD  (17*K-tr) VDD
+ (17*K+tr) VDD  (18*K-tr) VDD
+ (18*K+tr) VDD  (19*K-tr) VDD
+ (19*K+tr) VDD  (20*K-tr) VDD
+ (20*K+tr) VDD  (21*K-tr) VDD
+ (21*K+tr) VDD  (22*K-tr) VDD
+ (22*K+tr) VDD  (23*K-tr) VDD
+ (23*K+tr) VDD  (24*K-tr) VDD
+ (24*K+tr) VDD  (25*K-tr) VDD
+ (25*K+tr) VDD  (26*K-tr) VDD
+ (26*K+tr) VDD  (27*K-tr) VDD
+ (27*K+tr) VDD  (28*K-tr) VDD
+ (28*K+tr) VDD  (29*K-tr) VDD
+ (29*K+tr) VDD  (30*K-tr) VDD
+ (30*K+tr) VDD  (31*K-tr) VDD
+ (31*K+tr) VDD  (32*K-tr) VDD
+ (32*K+tr) VDD  (33*K-tr) VDD
+ (33*K+tr) VDD  (34*K-tr) VDD
+ (34*K+tr) VDD  (35*K-tr) VDD
+ (35*K+tr) VDD  (36*K-tr) VDD
+ (36*K+tr) VDD  (37*K-tr) VDD
+ (37*K+tr) VDD  (38*K-tr) VDD
+ (38*K+tr) VDD  (39*K-tr) VDD
+ (39*K+tr) VDD  (40*K-tr) VDD
+ (40*K+tr) VDD  (41*K-tr) VDD
+ (41*K+tr) VDD  (42*K-tr) VDD
+ (42*K+tr) VDD  (43*K-tr) VDD
+ (43*K+tr) VDD  (44*K-tr) VDD
+ (44*K+tr) VDD  (45*K-tr) VDD
+ (45*K+tr) VDD  (46*K-tr) VDD
+ (46*K+tr) VDD  (47*K-tr) VDD
+ (47*K+tr) VDD  (48*K-tr) VDD
+ (48*K+tr) VDD  (49*K-tr) VDD
+ (49*K+tr) VDD  (50*K-tr) VDD
+ (50*K+tr) VDD  (51*K-tr) VDD
+ (51*K+tr) VDD  (52*K-tr) VDD
+ (52*K+tr) 0    (53*K-tr) 0
+ (53*K+tr) VDD  (54*K-tr) VDD
+ (54*K+tr) VDD  (55*K-tr) VDD
+ (55*K+tr) VDD  (56*K-tr) VDD
+ (56*K+tr) VDD  (57*K-tr) VDD
+ (57*K+tr) VDD  (58*K-tr) VDD
+ (58*K+tr) VDD  (59*K-tr) VDD
+ (59*K+tr) VDD  (60*K-tr) VDD
+ (60*K+tr) VDD  (61*K-tr) VDD
+ (61*K+tr) 0    (62*K-tr) 0
+ (62*K+tr) VDD  (63*K-tr) VDD
+ (63*K+tr) VDD  (64*K-tr) VDD
+ (64*K+tr) VDD  (65*K-tr) VDD
+ (65*K+tr) VDD  (66*K-tr) VDD
+ (66*K+tr) VDD  (67*K-tr) VDD
+ (67*K+tr) VDD  (68*K-tr) VDD
+ (68*K+tr) VDD  (69*K-tr) VDD
+ (69*K+tr) VDD  (70*K-tr) VDD
+ (70*K+tr) VDD  (71*K-tr) VDD
+ (71*K+tr) VDD  (72*K-tr) VDD
+ (72*K+tr) VDD  (73*K-tr) VDD
+ (73*K+tr) VDD  (74*K-tr) VDD
+ (74*K+tr) VDD  (75*K-tr) VDD
+ (75*K+tr) VDD  (76*K-tr) VDD
+ (76*K+tr) VDD  (77*K-tr) VDD
+ (77*K+tr) 0    (78*K-tr) 0
+ (78*K+tr) VDD  (79*K-tr) VDD
+ (79*K+tr) VDD  (80*K-tr) VDD
+ (80*K+tr) VDD  (81*K-tr) VDD
+ (81*K+tr) VDD  (82*K-tr) VDD
+ (82*K+tr) VDD  (83*K-tr) VDD
+ (83*K+tr) VDD  (84*K-tr) VDD
+ (84*K+tr) VDD  (85*K-tr) VDD
+ (85*K+tr) VDD  (86*K-tr) VDD
+ (86*K+tr) 0    (87*K-tr) 0
+ (87*K+tr) VDD  (88*K-tr) VDD
+ (88*K+tr) VDD  (89*K-tr) VDD
+ (89*K+tr) VDD  (90*K-tr) VDD
+ (90*K+tr) VDD  (91*K-tr) VDD
+ (91*K+tr) VDD  (92*K-tr) VDD
+ (92*K+tr) VDD  (93*K-tr) VDD
+ (93*K+tr) VDD  (94*K-tr) VDD
+ (94*K+tr) VDD  (95*K-tr) VDD
+ (95*K+tr) 0    (96*K-tr) 0
+ (96*K+tr) VDD  (97*K-tr) VDD
+ (97*K+tr) VDD  (98*K-tr) VDD
+ (98*K+tr) VDD  (99*K-tr) VDD
+ (99*K+tr) VDD  (100*K-tr) VDD
+ (100*K+tr) VDD  (101*K-tr) VDD
+ (101*K+tr) VDD  (102*K-tr) VDD
+ (102*K+tr) VDD  (103*K-tr) VDD
+ (103*K+tr) VDD  (104*K-tr) VDD
+ (104*K+tr) VDD  (105*K-tr) VDD
+ (105*K+tr) VDD  (106*K-tr) VDD
+ (106*K+tr) 0    (107*K-tr) 0
+ (107*K+tr) VDD  (108*K-tr) VDD
+ (108*K+tr) VDD  (109*K-tr) VDD
+ (109*K+tr) 0    (110*K-tr) 0
+ (110*K+tr) VDD  (111*K-tr) VDD
+ (111*K+tr) VDD  (112*K-tr) VDD
+ (112*K+tr) VDD  (113*K-tr) VDD
+ (113*K+tr) VDD  (114*K-tr) VDD
+ (114*K+tr) VDD  (115*K-tr) VDD
+ (115*K+tr) 0    (116*K-tr) 0
+ (116*K+tr) VDD  (117*K-tr) VDD
+ (117*K+tr) VDD  (118*K-tr) VDD
+ (118*K+tr) 0    (119*K-tr) 0
+ (119*K+tr) VDD  (120*K-tr) VDD
+ (120*K+tr) VDD  (121*K-tr) VDD
+ (121*K+tr) VDD  (122*K-tr) VDD
+ (122*K+tr) VDD  (123*K-tr) VDD
+ (123*K+tr) VDD  (124*K-tr) VDD
+ (124*K+tr) 0    (125*K-tr) 0
+ (125*K+tr) VDD  (126*K-tr) VDD
+ (126*K+tr) VDD  (127*K-tr) VDD
+ (127*K+tr) 0    (128*K-tr) 0
+ (128*K+tr) VDD  (129*K-tr) VDD
+ (129*K+tr) VDD  (130*K-tr) VDD
+ (130*K+tr) VDD  (131*K-tr) VDD
+ (131*K+tr) VDD  (132*K-tr) VDD
+ (132*K+tr) VDD  (133*K-tr) VDD
+ (133*K+tr) 0    (134*K-tr) 0
+ (134*K+tr) VDD  (135*K-tr) VDD
+ (135*K+tr) VDD  (136*K-tr) VDD
+ (136*K+tr) 0    (137*K-tr) 0
+ (137*K+tr) VDD  (138*K-tr) VDD
+ (138*K+tr) VDD  (139*K-tr) VDD
+ (139*K+tr) VDD  (140*K-tr) VDD
+ (140*K+tr) VDD  (141*K-tr) VDD
+ (141*K+tr) VDD  (142*K-tr) VDD
+ (142*K+tr) VDD  (143*K-tr) VDD
+ (143*K+tr) VDD  (144*K-tr) VDD
+ (144*K+tr) VDD  (145*K-tr) VDD
+ (145*K+tr) VDD  (146*K-tr) VDD
+ (146*K+tr) VDD  (147*K-tr) VDD
+ (147*K+ 0*L+tr) VDD  (147*K+ 1*L-tr) VDD
+ (147*K+ 1*L+tr) VDD  (147*K+ 2*L-tr) VDD
+ (147*K+ 2*L+tr) VDD  (147*K+ 3*L-tr) VDD
+ (147*K+ 3*L+tr) VDD  (147*K+ 4*L-tr) VDD
+ (147*K+ 4*L+tr) VDD  (147*K+ 5*L-tr) VDD
+ (147*K+ 5*L+tr) VDD  (147*K+ 6*L-tr) VDD
+ (147*K+ 6*L+tr) VDD  (147*K+ 7*L-tr) VDD
+ (147*K+ 7*L+tr) VDD  (147*K+ 8*L-tr) VDD
+ (147*K+ 8*L+tr) VDD  (147*K+ 9*L-tr) VDD
+ (147*K+ 9*L+tr) VDD  (147*K+10*L-tr) VDD
+ (147*K+10*L+tr) VDD  (147*K+11*L-tr) VDD
+ (147*K+11*L+tr) VDD  (147*K+12*L-tr) VDD
+ (147*K+12*L+tr) VDD  (147*K+13*L-tr) VDD
+ (147*K+13*L+tr) VDD  (147*K+14*L-tr) VDD
+ ]
